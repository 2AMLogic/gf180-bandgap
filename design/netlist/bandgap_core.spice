** klt-netlist-inputs: {"pdk_variant": "gf180mcuD", "rcfile": "xschemrc", "xschem_version": "3.4.7"}
** sch_path: design/bandgap_core.sch
**.subckt bandgap_core vdd sns1 sns2 vss fb vref ibias casc

*.iopin vdd
*.iopin vss
*.iopin fb
*.iopin sns1
*.iopin sns2
*.iopin vref
*.iopin ibias
*.iopin casc
XM1 d1 fb vdd vdd pfet_03v3 L=8.5u W=85u nf=4 ad='int((nf+1)/2) * W/nf * 0.18u' as='int((nf+2)/2) * W/nf * 0.18u' pd='2*int((nf+1)/2) * (W/nf + 0.18u)'
+ ps='2*int((nf+2)/2) * (W/nf + 0.18u)' nrd='0.18u / W' nrs='0.18u / W' sa=0 sb=0 sd=0 m=1
XMC1 sns1 casc d1 vdd pfet_03v3 L=8.5u W=85u nf=4 ad='int((nf+1)/2) * W/nf * 0.18u' as='int((nf+2)/2) * W/nf * 0.18u' pd='2*int((nf+1)/2) * (W/nf + 0.18u)'
+ ps='2*int((nf+2)/2) * (W/nf + 0.18u)' nrd='0.18u / W' nrs='0.18u / W' sa=0 sb=0 sd=0 m=1
XQ1 vss vss sns1 pnp_05p00x05p00 m=1
XM2 d2 fb vdd vdd pfet_03v3 L=8.5u W=85u nf=4 ad='int((nf+1)/2) * W/nf * 0.18u' as='int((nf+2)/2) * W/nf * 0.18u' pd='2*int((nf+1)/2) * (W/nf + 0.18u)'
+ ps='2*int((nf+2)/2) * (W/nf + 0.18u)' nrd='0.18u / W' nrs='0.18u / W' sa=0 sb=0 sd=0 m=1
XMC2 sns2 casc d2 vdd pfet_03v3 L=8.5u W=85u nf=4 ad='int((nf+1)/2) * W/nf * 0.18u' as='int((nf+2)/2) * W/nf * 0.18u' pd='2*int((nf+1)/2) * (W/nf + 0.18u)'
+ ps='2*int((nf+2)/2) * (W/nf + 0.18u)' nrd='0.18u / W' nrs='0.18u / W' sa=0 sb=0 sd=0 m=1
XR2 e2 sns2 vss ppolyf_u r_width=2u r_length=39.195501u m=1
XQ2 vss vss e2 pnp_05p00x05p00 m=4
XM3 d3 fb vdd vdd pfet_03v3 L=8.5u W=85u nf=4 ad='int((nf+1)/2) * W/nf * 0.18u' as='int((nf+2)/2) * W/nf * 0.18u' pd='2*int((nf+1)/2) * (W/nf + 0.18u)'
+ ps='2*int((nf+2)/2) * (W/nf + 0.18u)' nrd='0.18u / W' nrs='0.18u / W' sa=0 sb=0 sd=0 m=1
XMC3 vref casc d3 vdd pfet_03v3 L=8.5u W=85u nf=4 ad='int((nf+1)/2) * W/nf * 0.18u' as='int((nf+2)/2) * W/nf * 0.18u' pd='2*int((nf+1)/2) * (W/nf + 0.18u)'
+ ps='2*int((nf+2)/2) * (W/nf + 0.18u)' nrd='0.18u / W' nrs='0.18u / W' sa=0 sb=0 sd=0 m=1
XR1 e3 tn0 vss ppolyf_u r_width=2u r_length=446.000000u m=1
XQ3 vss vss e3 pnp_05p00x05p00 m=1
XM4 d4 fb vdd vdd pfet_03v3 L=8.5u W=10.625u nf=1 ad='int((nf+1)/2) * W/nf * 0.18u' as='int((nf+2)/2) * W/nf * 0.18u' pd='2*int((nf+1)/2) * (W/nf + 0.18u)'
+ ps='2*int((nf+2)/2) * (W/nf + 0.18u)' nrd='0.18u / W' nrs='0.18u / W' sa=0 sb=0 sd=0 m=1
XMC4 ibias casc d4 vdd pfet_03v3 L=8.5u W=10.625u nf=1 ad='int((nf+1)/2) * W/nf * 0.18u' as='int((nf+2)/2) * W/nf * 0.18u' pd='2*int((nf+1)/2) * (W/nf + 0.18u)'
+ ps='2*int((nf+2)/2) * (W/nf + 0.18u)' nrd='0.18u / W' nrs='0.18u / W' sa=0 sb=0 sd=0 m=1
XM5 ibias ibias vss vss nfet_03v3 L=2u W=2.5u nf=1 ad='int((nf+1)/2) * W/nf * 0.18u' as='int((nf+2)/2) * W/nf * 0.18u' pd='2*int((nf+1)/2) * (W/nf + 0.18u)'
+ ps='2*int((nf+2)/2) * (W/nf + 0.18u)' nrd='0.18u / W' nrs='0.18u / W' sa=0 sb=0 sd=0 m=1
XMCB casc casc vdd vdd pfet_03v3 L=12u W=4u nf=1 ad='int((nf+1)/2) * W/nf * 0.18u' as='int((nf+2)/2) * W/nf * 0.18u' pd='2*int((nf+1)/2) * (W/nf + 0.18u)'
+ ps='2*int((nf+2)/2) * (W/nf + 0.18u)' nrd='0.18u / W' nrs='0.18u / W' sa=0 sb=0 sd=0 m=1
XMNB casc ibias vss vss nfet_03v3 L=2u W=5u nf=1 ad='int((nf+1)/2) * W/nf * 0.18u' as='int((nf+2)/2) * W/nf * 0.18u' pd='2*int((nf+1)/2) * (W/nf + 0.18u)'
+ ps='2*int((nf+2)/2) * (W/nf + 0.18u)' nrd='0.18u / W' nrs='0.18u / W' sa=0 sb=0 sd=0 m=1
XXTRIM tn0 vref vss bandgap_trim
**.ends

* expanding   symbol:  bandgap_trim.sym # of pins=3
** sym_path: design/bandgap_trim.sym
** sch_path: design/bandgap_trim.sch
.subckt bandgap_trim bot top sub

*.iopin bot
*.iopin top
*.iopin sub
**** begin user architecture code

.param trim_code=32

**** end user architecture code
XRU0 bot tn1 sub ppolyf_u r_width=2u r_length=2.771871u m=1
RS0 tn1 bot {1e-3 + 1e12*(floor(trim_code/1)-2*floor(trim_code/2))} m=1
XRU1 tn1 u1_0 sub ppolyf_u r_width=2u r_length=2.771871u m=1
XRU2 u1_0 tn2 sub ppolyf_u r_width=2u r_length=2.771871u m=1
RS1 tn2 tn1 {1e-3 + 1e12*(floor(trim_code/2)-2*floor(trim_code/4))} m=1
XRU3 tn2 u2_0 sub ppolyf_u r_width=2u r_length=2.771871u m=1
XRU4 u2_0 u2_1 sub ppolyf_u r_width=2u r_length=2.771871u m=1
XRU5 u2_1 u2_2 sub ppolyf_u r_width=2u r_length=2.771871u m=1
XRU6 u2_2 tn3 sub ppolyf_u r_width=2u r_length=2.771871u m=1
RS2 tn3 tn2 {1e-3 + 1e12*(floor(trim_code/4)-2*floor(trim_code/8))} m=1
XRU7 tn3 u3_0 sub ppolyf_u r_width=2u r_length=2.771871u m=1
XRU8 u3_0 u3_1 sub ppolyf_u r_width=2u r_length=2.771871u m=1
XRU9 u3_1 u3_2 sub ppolyf_u r_width=2u r_length=2.771871u m=1
XRU10 u3_2 u3_3 sub ppolyf_u r_width=2u r_length=2.771871u m=1
XRU11 u3_3 u3_4 sub ppolyf_u r_width=2u r_length=2.771871u m=1
XRU12 u3_4 u3_5 sub ppolyf_u r_width=2u r_length=2.771871u m=1
XRU13 u3_5 u3_6 sub ppolyf_u r_width=2u r_length=2.771871u m=1
XRU14 u3_6 tn4 sub ppolyf_u r_width=2u r_length=2.771871u m=1
RS3 tn4 tn3 {1e-3 + 1e12*(floor(trim_code/8)-2*floor(trim_code/16))} m=1
XRU15 tn4 u4_0 sub ppolyf_u r_width=2u r_length=2.771871u m=1
XRU16 u4_0 u4_1 sub ppolyf_u r_width=2u r_length=2.771871u m=1
XRU17 u4_1 u4_2 sub ppolyf_u r_width=2u r_length=2.771871u m=1
XRU18 u4_2 u4_3 sub ppolyf_u r_width=2u r_length=2.771871u m=1
XRU19 u4_3 u4_4 sub ppolyf_u r_width=2u r_length=2.771871u m=1
XRU20 u4_4 u4_5 sub ppolyf_u r_width=2u r_length=2.771871u m=1
XRU21 u4_5 u4_6 sub ppolyf_u r_width=2u r_length=2.771871u m=1
XRU22 u4_6 u4_7 sub ppolyf_u r_width=2u r_length=2.771871u m=1
XRU23 u4_7 u4_8 sub ppolyf_u r_width=2u r_length=2.771871u m=1
XRU24 u4_8 u4_9 sub ppolyf_u r_width=2u r_length=2.771871u m=1
XRU25 u4_9 u4_10 sub ppolyf_u r_width=2u r_length=2.771871u m=1
XRU26 u4_10 u4_11 sub ppolyf_u r_width=2u r_length=2.771871u m=1
XRU27 u4_11 u4_12 sub ppolyf_u r_width=2u r_length=2.771871u m=1
XRU28 u4_12 u4_13 sub ppolyf_u r_width=2u r_length=2.771871u m=1
XRU29 u4_13 u4_14 sub ppolyf_u r_width=2u r_length=2.771871u m=1
XRU30 u4_14 tn5 sub ppolyf_u r_width=2u r_length=2.771871u m=1
RS4 tn5 tn4 {1e-3 + 1e12*(floor(trim_code/16)-2*floor(trim_code/32))} m=1
XRU31 tn5 u5_0 sub ppolyf_u r_width=2u r_length=2.771871u m=1
XRU32 u5_0 u5_1 sub ppolyf_u r_width=2u r_length=2.771871u m=1
XRU33 u5_1 u5_2 sub ppolyf_u r_width=2u r_length=2.771871u m=1
XRU34 u5_2 u5_3 sub ppolyf_u r_width=2u r_length=2.771871u m=1
XRU35 u5_3 u5_4 sub ppolyf_u r_width=2u r_length=2.771871u m=1
XRU36 u5_4 u5_5 sub ppolyf_u r_width=2u r_length=2.771871u m=1
XRU37 u5_5 u5_6 sub ppolyf_u r_width=2u r_length=2.771871u m=1
XRU38 u5_6 u5_7 sub ppolyf_u r_width=2u r_length=2.771871u m=1
XRU39 u5_7 u5_8 sub ppolyf_u r_width=2u r_length=2.771871u m=1
XRU40 u5_8 u5_9 sub ppolyf_u r_width=2u r_length=2.771871u m=1
XRU41 u5_9 u5_10 sub ppolyf_u r_width=2u r_length=2.771871u m=1
XRU42 u5_10 u5_11 sub ppolyf_u r_width=2u r_length=2.771871u m=1
XRU43 u5_11 u5_12 sub ppolyf_u r_width=2u r_length=2.771871u m=1
XRU44 u5_12 u5_13 sub ppolyf_u r_width=2u r_length=2.771871u m=1
XRU45 u5_13 u5_14 sub ppolyf_u r_width=2u r_length=2.771871u m=1
XRU46 u5_14 u5_15 sub ppolyf_u r_width=2u r_length=2.771871u m=1
XRU47 u5_15 u5_16 sub ppolyf_u r_width=2u r_length=2.771871u m=1
XRU48 u5_16 u5_17 sub ppolyf_u r_width=2u r_length=2.771871u m=1
XRU49 u5_17 u5_18 sub ppolyf_u r_width=2u r_length=2.771871u m=1
XRU50 u5_18 u5_19 sub ppolyf_u r_width=2u r_length=2.771871u m=1
XRU51 u5_19 u5_20 sub ppolyf_u r_width=2u r_length=2.771871u m=1
XRU52 u5_20 u5_21 sub ppolyf_u r_width=2u r_length=2.771871u m=1
XRU53 u5_21 u5_22 sub ppolyf_u r_width=2u r_length=2.771871u m=1
XRU54 u5_22 u5_23 sub ppolyf_u r_width=2u r_length=2.771871u m=1
XRU55 u5_23 u5_24 sub ppolyf_u r_width=2u r_length=2.771871u m=1
XRU56 u5_24 u5_25 sub ppolyf_u r_width=2u r_length=2.771871u m=1
XRU57 u5_25 u5_26 sub ppolyf_u r_width=2u r_length=2.771871u m=1
XRU58 u5_26 u5_27 sub ppolyf_u r_width=2u r_length=2.771871u m=1
XRU59 u5_27 u5_28 sub ppolyf_u r_width=2u r_length=2.771871u m=1
XRU60 u5_28 u5_29 sub ppolyf_u r_width=2u r_length=2.771871u m=1
XRU61 u5_29 u5_30 sub ppolyf_u r_width=2u r_length=2.771871u m=1
XRU62 u5_30 top sub ppolyf_u r_width=2u r_length=2.771871u m=1
RS5 top tn5 {1e-3 + 1e12*(floor(trim_code/32)-2*floor(trim_code/64))} m=1
.ends

.end
