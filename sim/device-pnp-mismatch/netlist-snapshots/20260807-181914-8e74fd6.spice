* tb_pnp_mismatch.spice -- gf180mcu vertical-PNP local-mismatch Monte Carlo
*
* Device-level offset-budget input alongside sim/device-mos-mismatch/: the
* gf180mcu `bjt_mc` subcircuits carry per-instance agauss() mismatch on
* saturation current (`mis_is_pnp_*`) and beta (`mis_bf_pnp_*`), gated by
* `sw_stat_mismatch`, exactly like the `fets_mm` wrappers
* tb_mos_mismatch.spice already exercises for MOS. This testbench applies the
* same Monte Carlo pattern to the vertical PNP pair the Brokaw core (DR-0001)
* actually uses.
*
* Two claims, each at two representative bias currents (1 uA and 10 uA,
* per #25's precision note -- #8's core schematic has not ratified a bias
* point yet, so these mirror the candidate biases sim/device-pnp-vbe/ already
* calls out):
*   (a) identical pair: two pnp_05p00x05p00 devices at equal emitter current
*       -- the pair-offset number an amplifier input or current mirror built
*       from this device would see.
*   (b) area-ratioed pair: pnp_05p00x05p00 / pnp_10p00x10p00 at equal emitter
*       current -- the actual Brokaw-core PTAT pair (sim/device-pnp-vbe/'s
*       dVBE ~ 33.4 mV signal), so the dVBE mismatch reported here is directly
*       comparable to that signal.
*
* Every device is diode-connected in the bandgap-core configuration: collector
* and base tied to the p-substrate ground, emitter driven by an ideal current
* source (same topology as tb_pnp_vbe.spice, minus the base-current sense
* source, which this testbench does not need).
*
* Statistical setup: `sw_stat_mismatch = 1` (local/intra-die variation only),
* `sw_stat_global` left at the PDK default of 0 -- the gf180mcu convention
* documented in design.ngspice, and the same convention tb_mos_mismatch.spice
* uses. Process section is `bjt_typical` (the nominal BJT process point) only
* -- deliberately NOT stacked on the bjt_ss/bjt_typical/bjt_ff corner axis
* sim/device-pnp-vbe/ already sweeps; doing so would double-count that
* record's global-corner spread against this record's local-mismatch spread.
*
* The mismatch parameters are drawn per X-instance (agauss() is evaluated
* inside each `.subckt pnp_* ... .param` block), so two instantiations of the
* same subckt name already get independent draws -- no extra plumbing needed.
* ngspice re-draws them on `reset`, so the control loop below is a genuine
* Monte Carlo; `setseed` makes the run reproducible.
*
* No supply rail: every DUT is referred to its own emitter node at ground.
*
* This is a *fragment*, per sim/harness/README.md's testbench convention: no
* .include, .lib, .temp, .control, .end -- sim/harness supplies the PDK
* models, the corner .lib section(s), .temp and the measurement control
* block (see tb.json's "measure" map). run_pnp_mismatch.py drives the full
* N=300, seeded Monte Carlo loop (a `dowhile`/`reset` control block, not a
* single PVT point) directly against sim/harness's library (pdk.py,
* runner.py, report.py, corners.py); `python3 sim/run_corners.py
* device-pnp-mismatch` runs this same fragment through the harness's generic
* single-grid CLI as a secondary, representative check that reports one
* (un-reproducible, single-draw) sample instead of the full distribution --
* see tb.json's description.
*
* Run via: sim/device-pnp-mismatch/run_pnp_mismatch.py

* Local mismatch on, global process variation off (see header).
.param sw_stat_mismatch = 1

* ---- identical pair: pnp_05p00x05p00 x2, 1 uA ----
Ia1a 0 ea1a 1u
XA1a 0 0 ea1a pnp_05p00x05p00
Ia1b 0 ea1b 1u
XA1b 0 0 ea1b pnp_05p00x05p00

* ---- identical pair: pnp_05p00x05p00 x2, 10 uA ----
Ia10a 0 ea10a 10u
XA10a 0 0 ea10a pnp_05p00x05p00
Ia10b 0 ea10b 10u
XA10b 0 0 ea10b pnp_05p00x05p00

* ---- area-ratioed pair: pnp_05p00x05p00 / pnp_10p00x10p00, 1 uA ----
Ir1a 0 er1a 1u
XR1a 0 0 er1a pnp_05p00x05p00
Ir1b 0 er1b 1u
XR1b 0 0 er1b pnp_10p00x10p00

* ---- area-ratioed pair: pnp_05p00x05p00 / pnp_10p00x10p00, 10 uA ----
Ir10a 0 er10a 10u
XR10a 0 0 er10a pnp_05p00x05p00
Ir10b 0 er10b 10u
XR10b 0 0 er10b pnp_10p00x10p00
