* Frozen netlist snapshot for record 20260801-032751-82ea7db
* source     : sim/line-regulation/testbench/tb_line_regulation.spice
* sha256     : 6c4742c6fb62d5a9adfcce53f299043b527d63bc0b9be0f51d377f756d670e7e
* This is a verbatim copy taken at record time. Do not edit.
* line-regulation -- Vref vs supply over the ratified 2.97..3.63 V range
*
* Netlist FRAGMENT for sim/harness (see sim/harness/README.md). The DUT is
* .include-d from the manifest's "dut" key, so this testbench re-runs
* unedited against a frozen or extracted netlist via `--dut <path>`.
*
* Measurement convention:
*
*   - The supply is swept CONTINUOUSLY inside the testbench --
*     `dc vsup 2.97 3.63 0.005`, 133 points at 5 mV -- rather than visiting
*     the harness's three outer supply rails. A three-point evaluation can
*     step straight over a local nonmonotonicity (a mirror leaving
*     saturation, a cascode losing headroom); the dense sweep cannot.
*   - Line regulation is reported as the box over that range:
*
*        (Vref_max - Vref_min) / (3.63 V - 2.97 V)   [mV/V]
*
*     i.e. worst-case sensitivity across the whole range, not the chord
*     between the two endpoints. vref_lo/vref_hi record the endpoints too,
*     so the record shows both readings.
*   - The same sweep also confirms the accuracy window: vref_min/vref_max
*     must stay inside 1.176-1.224 V at every point of the supply range,
*     which is the "supply 3.3 V +/-10%" aspect of the output-reference row.
*
* Because the supply axis is swept here, the harness's own supply axis is
* collapsed to the nominal rail (supply_tolerance 0 in the manifest) -- the
* manifest carries the written justification the record must state, and
* re-running the outer axis would only repeat this identical sweep three
* times. Process and temperature are still the full mandated axes.

vsup vdd 0 dc {vdd_val}
Xdut vdd 0 vref bandgap_top

* Convergence seeding; see design/bandgap_operating_point.md 4.2 and #11.
* The sweep starts at 2.97 V, the ratified worst-case headroom rail, so a
* corner that cannot hold the intended state at the bottom of the supply
* range shows up as a vref outside the window rather than as a flat,
* suspiciously good regulation number.
.ic v(xdut.fb)=1.0 v(xdut.sns1)=0.6 v(xdut.sns2)=0.6 v(vref)=1.2
+ v(xdut.ibias)=0.6 v(xdut.xx1.casc)=1.8

* ---------------------------------------------------------------
* DUT netlist included by this testbench (schematic)
* source     : sim/dut/bandgap_top.spice
* sha256     : 324384fd617fed86b7699c10b3d1bf354c0716c607495042f8274aec8f9a9733
* ---------------------------------------------------------------

* DUT netlist fragment -- GENERATED, do not edit by hand.
*
* source     : design/netlist/bandgap_top.spice
* sha256     : 16a219236ffbda6454eeafca3270965a8743ce5979d82b6c36c4312621990149
* regenerate : python3 sim/tools/mk_dut.py design/netlist/bandgap_top.spice <this file>
*
* Subcircuits defined here: bandgap_top, bandgap_core, bandgap_amp
*
* Included by the corner runner ahead of each testbench (tb.json's
* "dut" key, or --dut). Holds subcircuit definitions only: no .end,
* .control, .temp or .lib -- the harness owns those per PVT point.

** sch_path: /Users/rwalters/GitHub/gf180-bandgap/.loom/worktrees/issue-8/design/bandgap_top.sch
.subckt bandgap_top vdd vss vref

*.iopin vdd
*.iopin vss
*.iopin vref
Xx1 vdd sns1 sns2 vss fb vref ibias bandgap_core
Xx2 sns2 sns1 vss fb vdd ibias bandgap_amp
.ends

* expanding   symbol:  bandgap_core.sym # of pins=7
** sym_path: /Users/rwalters/GitHub/gf180-bandgap/.loom/worktrees/issue-8/design/bandgap_core.sym
** sch_path: /Users/rwalters/GitHub/gf180-bandgap/.loom/worktrees/issue-8/design/bandgap_core.sch
.subckt bandgap_core vdd sns1 sns2 vss fb vref ibias

*.iopin vdd
*.iopin vss
*.iopin fb
*.iopin sns1
*.iopin sns2
*.iopin vref
*.iopin ibias
XM1 d1 fb vdd vdd pfet_03v3 L=2u W=20u nf=1 ad='int((nf+1)/2) * W/nf * 0.18u' as='int((nf+2)/2) * W/nf * 0.18u' pd='2*int((nf+1)/2) * (W/nf + 0.18u)'
+ ps='2*int((nf+2)/2) * (W/nf + 0.18u)' nrd='0.18u / W' nrs='0.18u / W' sa=0 sb=0 sd=0 m=1
XMC1 sns1 casc d1 vdd pfet_03v3 L=2u W=20u nf=1 ad='int((nf+1)/2) * W/nf * 0.18u' as='int((nf+2)/2) * W/nf * 0.18u' pd='2*int((nf+1)/2) * (W/nf + 0.18u)'
+ ps='2*int((nf+2)/2) * (W/nf + 0.18u)' nrd='0.18u / W' nrs='0.18u / W' sa=0 sb=0 sd=0 m=1
XQ1 vss vss sns1 pnp_05p00x05p00 m=1
XM2 d2 fb vdd vdd pfet_03v3 L=2u W=20u nf=1 ad='int((nf+1)/2) * W/nf * 0.18u' as='int((nf+2)/2) * W/nf * 0.18u' pd='2*int((nf+1)/2) * (W/nf + 0.18u)'
+ ps='2*int((nf+2)/2) * (W/nf + 0.18u)' nrd='0.18u / W' nrs='0.18u / W' sa=0 sb=0 sd=0 m=1
XMC2 sns2 casc d2 vdd pfet_03v3 L=2u W=20u nf=1 ad='int((nf+1)/2) * W/nf * 0.18u' as='int((nf+2)/2) * W/nf * 0.18u' pd='2*int((nf+1)/2) * (W/nf + 0.18u)'
+ ps='2*int((nf+2)/2) * (W/nf + 0.18u)' nrd='0.18u / W' nrs='0.18u / W' sa=0 sb=0 sd=0 m=1
XR2 e2 sns2 vss ppolyf_u r_width=2u r_length=18u m=1
XQ2 vss vss e2 pnp_10p00x10p00 m=1
XM3 d3 fb vdd vdd pfet_03v3 L=2u W=20u nf=1 ad='int((nf+1)/2) * W/nf * 0.18u' as='int((nf+2)/2) * W/nf * 0.18u' pd='2*int((nf+1)/2) * (W/nf + 0.18u)'
+ ps='2*int((nf+2)/2) * (W/nf + 0.18u)' nrd='0.18u / W' nrs='0.18u / W' sa=0 sb=0 sd=0 m=1
XMC3 vref casc d3 vdd pfet_03v3 L=2u W=20u nf=1 ad='int((nf+1)/2) * W/nf * 0.18u' as='int((nf+2)/2) * W/nf * 0.18u' pd='2*int((nf+1)/2) * (W/nf + 0.18u)'
+ ps='2*int((nf+2)/2) * (W/nf + 0.18u)' nrd='0.18u / W' nrs='0.18u / W' sa=0 sb=0 sd=0 m=1
XR1 e3 vref vss ppolyf_u r_width=2u r_length=280u m=1
XQ3 vss vss e3 pnp_05p00x05p00 m=1
XM4 d4 fb vdd vdd pfet_03v3 L=2u W=20u nf=1 ad='int((nf+1)/2) * W/nf * 0.18u' as='int((nf+2)/2) * W/nf * 0.18u' pd='2*int((nf+1)/2) * (W/nf + 0.18u)'
+ ps='2*int((nf+2)/2) * (W/nf + 0.18u)' nrd='0.18u / W' nrs='0.18u / W' sa=0 sb=0 sd=0 m=1
XMC4 ibias casc d4 vdd pfet_03v3 L=2u W=20u nf=1 ad='int((nf+1)/2) * W/nf * 0.18u' as='int((nf+2)/2) * W/nf * 0.18u' pd='2*int((nf+1)/2) * (W/nf + 0.18u)'
+ ps='2*int((nf+2)/2) * (W/nf + 0.18u)' nrd='0.18u / W' nrs='0.18u / W' sa=0 sb=0 sd=0 m=1
XM5 ibias ibias vss vss nfet_03v3 L=2u W=20u nf=1 ad='int((nf+1)/2) * W/nf * 0.18u' as='int((nf+2)/2) * W/nf * 0.18u' pd='2*int((nf+1)/2) * (W/nf + 0.18u)'
+ ps='2*int((nf+2)/2) * (W/nf + 0.18u)' nrd='0.18u / W' nrs='0.18u / W' sa=0 sb=0 sd=0 m=1
XMCB casc casc vdd vdd pfet_03v3 L=12u W=4u nf=1 ad='int((nf+1)/2) * W/nf * 0.18u' as='int((nf+2)/2) * W/nf * 0.18u' pd='2*int((nf+1)/2) * (W/nf + 0.18u)'
+ ps='2*int((nf+2)/2) * (W/nf + 0.18u)' nrd='0.18u / W' nrs='0.18u / W' sa=0 sb=0 sd=0 m=1
XMNB casc ibias vss vss nfet_03v3 L=2u W=5u nf=1 ad='int((nf+1)/2) * W/nf * 0.18u' as='int((nf+2)/2) * W/nf * 0.18u' pd='2*int((nf+1)/2) * (W/nf + 0.18u)'
+ ps='2*int((nf+2)/2) * (W/nf + 0.18u)' nrd='0.18u / W' nrs='0.18u / W' sa=0 sb=0 sd=0 m=1
.ends

* expanding   symbol:  bandgap_amp.sym # of pins=6
** sym_path: /Users/rwalters/GitHub/gf180-bandgap/.loom/worktrees/issue-8/design/bandgap_amp.sym
** sch_path: /Users/rwalters/GitHub/gf180-bandgap/.loom/worktrees/issue-8/design/bandgap_amp.sch
.subckt bandgap_amp in_p in_n vss out vdd tail_bias

*.iopin vdd
*.iopin vss
*.iopin in_p
*.iopin in_n
*.iopin out
*.iopin tail_bias
XM1 nd1 in_p tail vss nfet_03v3 L=4u W=10u nf=1 ad='int((nf+1)/2) * W/nf * 0.18u' as='int((nf+2)/2) * W/nf * 0.18u' pd='2*int((nf+1)/2) * (W/nf + 0.18u)'
+ ps='2*int((nf+2)/2) * (W/nf + 0.18u)' nrd='0.18u / W' nrs='0.18u / W' sa=0 sb=0 sd=0 m=1
XM2 out in_n tail vss nfet_03v3 L=4u W=10u nf=1 ad='int((nf+1)/2) * W/nf * 0.18u' as='int((nf+2)/2) * W/nf * 0.18u' pd='2*int((nf+1)/2) * (W/nf + 0.18u)'
+ ps='2*int((nf+2)/2) * (W/nf + 0.18u)' nrd='0.18u / W' nrs='0.18u / W' sa=0 sb=0 sd=0 m=1
XM3 nd1 nd1 vdd vdd pfet_03v3 L=4u W=10u nf=1 ad='int((nf+1)/2) * W/nf * 0.18u' as='int((nf+2)/2) * W/nf * 0.18u' pd='2*int((nf+1)/2) * (W/nf + 0.18u)'
+ ps='2*int((nf+2)/2) * (W/nf + 0.18u)' nrd='0.18u / W' nrs='0.18u / W' sa=0 sb=0 sd=0 m=1
XM4 out nd1 vdd vdd pfet_03v3 L=4u W=10u nf=1 ad='int((nf+1)/2) * W/nf * 0.18u' as='int((nf+2)/2) * W/nf * 0.18u' pd='2*int((nf+1)/2) * (W/nf + 0.18u)'
+ ps='2*int((nf+2)/2) * (W/nf + 0.18u)' nrd='0.18u / W' nrs='0.18u / W' sa=0 sb=0 sd=0 m=1
XM5 tail tail_bias vss vss nfet_03v3 L=4u W=10u nf=1 ad='int((nf+1)/2) * W/nf * 0.18u' as='int((nf+2)/2) * W/nf * 0.18u' pd='2*int((nf+1)/2) * (W/nf + 0.18u)'
+ ps='2*int((nf+2)/2) * (W/nf + 0.18u)' nrd='0.18u / W' nrs='0.18u / W' sa=0 sb=0 sd=0 m=1
.ends
