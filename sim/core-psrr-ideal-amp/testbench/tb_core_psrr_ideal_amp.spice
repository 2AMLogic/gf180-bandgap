* core-psrr-ideal-amp -- issue #10 diagnostic: isolate bandgap_core's own
*
* CORE RE-SYNCED TO THE DR-0007 FINAL CORE IN #227 -- RECORDS TAKEN BEFORE
* AND AFTER ARE NOT COMPARABLE. The embedded core now carries sim/dut/
* bandgap_top.spice's values (as of #222): R2 ppolyf_u W=2u L=39.195501u,
* Q2 pnp_05p00x05p00 m=4 (was pnp_10p00x10p00 m=1, R2 L=36.341871u), base
* R1 L=446.000000u. R1 is lumped here (R1 + 32 trim units, trim code 32) in
* ONE ppolyf_u: L=545.639857u, solved against the real PDK model (R = a*L + b
* overhead, so NOT 446u and NOT 446u + 32 units) -- exact at tt/27 C, residual
* -0.18%/+0.27% at -40/125 C. See sim/embedded-core-inventory.md and
* sim/tools/{measure_lumped_r1,check_embedded_cores}.py. Diagnostic topology
* below is unchanged. No signoff claim; full-suite PVT is #211.
*
* CORE RESIZED IN #61 -- RECORDS TAKEN BEFORE AND AFTER ARE NOT COMPARABLE.
* The bandgap_core copy embedded below carries #61's R1/R2 co-scaling: both
* the PTAT resistor R2 and the output-branch summing resistor R1 (here in
* its pre-trim lumped form, electrically R1 + 32 trim units at the default
* code) are scaled by k = 2, halving the design current I = dVBE/R2 while
* holding I*R1 and the R1/R2 ratio fixed. See design/bandgap_core.sch's
* header and design/bandgap_error_budget.md Sec 5 for the derivation.
* PSRR contribution from the real amp's, by replacing bandgap_amp with an
* idealized infinite-gain, supply-independent servo (a linear
* controlled-source, `Efb`) that forces sns1=sns2 exactly, with no
* dependence on vdd of its own.
*
* NOT a spec claim and NOT a substitute for sim/amp-psrr/ (an idealized
* amp is explicitly out of scope for a spec-conformance result per
* design/bandgap_operating_point.md Sec 6 / CLAUDE.md "no claim without a
* testbench" applied to the real devices). This experiment exists only to
* answer a decomposition question for design/bandgap_error_budget.md Sec
* 3: is bandgap_core's own cascoded output stage (DR-0001) or the amp
* (#10's scope) the dominant limiter of the whole loop's DC-1kHz PSRR? An
* ideal amp has, by construction, zero input-referred offset and zero
* supply sensitivity of its own -- so whatever PSRR shortfall remains here
* is 100% attributable to bandgap_core, and by elimination, whatever
* *additional* shortfall sim/amp-psrr/ shows on top of this number is
* attributable to the real amp.
*
* Netlist FRAGMENT for sim/harness (sim/README.md format); same
* .subckt bandgap_core body as sim/amp-psrr/testbench/tb_psrr.spice, with
* Efb replacing Xamp bandgap_amp entirely (no bandgap_amp instantiation
* in this file at all -- this is not a mismeasurement of the real amp,
* it is a different circuit built to answer a different question).

.subckt bandgap_core vdd sns1 sns2 vss fb vref ibias
XM1 d1 fb vdd vdd pfet_03v3 L=6u W=60u nf=4 ad='int((nf+1)/2) * W/nf * 0.18u' as='int((nf+2)/2) * W/nf * 0.18u' pd='2*int((nf+1)/2) * (W/nf + 0.18u)'
+ ps='2*int((nf+2)/2) * (W/nf + 0.18u)' nrd='0.18u / W' nrs='0.18u / W' sa=0 sb=0 sd=0 m=1
XMC1 sns1 casc d1 vdd pfet_03v3 L=6u W=60u nf=4 ad='int((nf+1)/2) * W/nf * 0.18u' as='int((nf+2)/2) * W/nf * 0.18u' pd='2*int((nf+1)/2) * (W/nf + 0.18u)'
+ ps='2*int((nf+2)/2) * (W/nf + 0.18u)' nrd='0.18u / W' nrs='0.18u / W' sa=0 sb=0 sd=0 m=1
XQ1 vss vss sns1 pnp_05p00x05p00 m=1
XM2 d2 fb vdd vdd pfet_03v3 L=6u W=60u nf=4 ad='int((nf+1)/2) * W/nf * 0.18u' as='int((nf+2)/2) * W/nf * 0.18u' pd='2*int((nf+1)/2) * (W/nf + 0.18u)'
+ ps='2*int((nf+2)/2) * (W/nf + 0.18u)' nrd='0.18u / W' nrs='0.18u / W' sa=0 sb=0 sd=0 m=1
XMC2 sns2 casc d2 vdd pfet_03v3 L=6u W=60u nf=4 ad='int((nf+1)/2) * W/nf * 0.18u' as='int((nf+2)/2) * W/nf * 0.18u' pd='2*int((nf+1)/2) * (W/nf + 0.18u)'
+ ps='2*int((nf+2)/2) * (W/nf + 0.18u)' nrd='0.18u / W' nrs='0.18u / W' sa=0 sb=0 sd=0 m=1
XR2 e2 sns2 vss ppolyf_u r_width=2u r_length=39.195501u m=1
XQ2 vss vss e2 pnp_05p00x05p00 m=4
XM3 d3 fb vdd vdd pfet_03v3 L=6u W=60u nf=4 ad='int((nf+1)/2) * W/nf * 0.18u' as='int((nf+2)/2) * W/nf * 0.18u' pd='2*int((nf+1)/2) * (W/nf + 0.18u)'
+ ps='2*int((nf+2)/2) * (W/nf + 0.18u)' nrd='0.18u / W' nrs='0.18u / W' sa=0 sb=0 sd=0 m=1
XMC3 vref casc d3 vdd pfet_03v3 L=6u W=60u nf=4 ad='int((nf+1)/2) * W/nf * 0.18u' as='int((nf+2)/2) * W/nf * 0.18u' pd='2*int((nf+1)/2) * (W/nf + 0.18u)'
+ ps='2*int((nf+2)/2) * (W/nf + 0.18u)' nrd='0.18u / W' nrs='0.18u / W' sa=0 sb=0 sd=0 m=1
XR1 e3 vref vss ppolyf_u r_width=2u r_length=545.639857u m=1
XQ3 vss vss e3 pnp_05p00x05p00 m=1
XM4 d4 fb vdd vdd pfet_03v3 L=6u W=7.5u nf=1 ad='int((nf+1)/2) * W/nf * 0.18u' as='int((nf+2)/2) * W/nf * 0.18u' pd='2*int((nf+1)/2) * (W/nf + 0.18u)'
+ ps='2*int((nf+2)/2) * (W/nf + 0.18u)' nrd='0.18u / W' nrs='0.18u / W' sa=0 sb=0 sd=0 m=1
XMC4 ibias casc d4 vdd pfet_03v3 L=6u W=7.5u nf=1 ad='int((nf+1)/2) * W/nf * 0.18u' as='int((nf+2)/2) * W/nf * 0.18u' pd='2*int((nf+1)/2) * (W/nf + 0.18u)'
+ ps='2*int((nf+2)/2) * (W/nf + 0.18u)' nrd='0.18u / W' nrs='0.18u / W' sa=0 sb=0 sd=0 m=1
XM5 ibias ibias vss vss nfet_03v3 L=2u W=2.5u nf=1 ad='int((nf+1)/2) * W/nf * 0.18u' as='int((nf+2)/2) * W/nf * 0.18u' pd='2*int((nf+1)/2) * (W/nf + 0.18u)'
+ ps='2*int((nf+2)/2) * (W/nf + 0.18u)' nrd='0.18u / W' nrs='0.18u / W' sa=0 sb=0 sd=0 m=1
XMCB casc casc vdd vdd pfet_03v3 L=12u W=4u nf=1 ad='int((nf+1)/2) * W/nf * 0.18u' as='int((nf+2)/2) * W/nf * 0.18u' pd='2*int((nf+1)/2) * (W/nf + 0.18u)'
+ ps='2*int((nf+2)/2) * (W/nf + 0.18u)' nrd='0.18u / W' nrs='0.18u / W' sa=0 sb=0 sd=0 m=1
XMNB casc ibias vss vss nfet_03v3 L=2u W=5u nf=1 ad='int((nf+1)/2) * W/nf * 0.18u' as='int((nf+2)/2) * W/nf * 0.18u' pd='2*int((nf+1)/2) * (W/nf + 0.18u)'
+ ps='2*int((nf+2)/2) * (W/nf + 0.18u)' nrd='0.18u / W' nrs='0.18u / W' sa=0 sb=0 sd=0 m=1
.ends

vsup vdd 0 dc {vdd_val} ac 1
Xcore vdd sns1 sns2 0 fb vref ibias bandgap_core
* Idealized servo: fb = 1e6 * (sns2 - sns1), no offset, no vdd dependence.
Efb fb 0 sns2 sns1 1e6

.ic v(fb)=2.27 v(sns1)=0.72 v(sns2)=0.72 v(vref)=1.22 v(ibias)=0.6
+ v(xcore.casc)=1.75
* #227: with the DR-0007 Q2 (pnp_05p00x05p00 m=4) the DC .op seeded only by
* the .ic above lands on a degenerate branch of the 1e6-gain servo (fb in
* the MV range, vref ~ vdd, PSRR ~ 0 dB). The nodeset below is the tt/27 C
* physical operating point of this exact deck (vref ~ 1.2 V) and, with the
* raised iteration limits, steers the .op onto that branch at -40/27/125 C.
* These are convergence aids only: no stimulus, topology or threshold moved.
.options itl1=1000 itl2=1000 itl6=1000
.nodeset v(xcore.d1)=3.037 v(xcore.d2)=3.037 v(xcore.d3)=3.037 v(xcore.d4)=3.037
+ v(xcore.e2)=0.669 v(xcore.e3)=0.705 v(vref)=1.202 v(fb)=2.353
+ v(sns1)=0.705 v(sns2)=0.705 v(ibias)=0.7093 v(xcore.casc)=1.97
