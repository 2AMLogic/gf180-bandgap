* klt sim -- generated corner deck, do not edit
.lib /opt/pdk/gf180mcuD/libs.tech/ngspice/sm141064.ngspice bjt_ff
.include /var/tmp/eda-job-klt-sim-3824cc566e15/inputs/netlist.cir
.temp 27.0
.meas dc vbe_u_4 FIND v(eu) AT=4
.meas dc vbe_a_4 FIND v(ea) AT=4
.meas dc vbe_m_4 FIND v(em) AT=4
.meas dc vbe_u_5p07 FIND v(eu) AT=5.07
.meas dc vbe_a_5p07 FIND v(ea) AT=5.07
.meas dc vbe_m_5p07 FIND v(em) AT=5.07
.meas dc vbe_u_6p5 FIND v(eu) AT=6.5
.meas dc vbe_a_6p5 FIND v(ea) AT=6.5
.meas dc vbe_m_6p5 FIND v(em) AT=6.5
.control
dc Vctrl 4.0 7.0 0.01
quit
.endc
.end
