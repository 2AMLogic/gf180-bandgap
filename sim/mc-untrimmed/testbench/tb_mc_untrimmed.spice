* tb_mc_untrimmed.spice -- issue #13 Monte Carlo mismatch analysis for the
* untrimmed accuracy claim (README.md's "Output reference" row: 1.20 V +/-2%
* untrimmed, 3-sigma, mismatch MC N>=300 + process corners, -40..125 C).
*
* This deck simulates the full bandgap_top DUT (design/netlist/bandgap_top.spice,
* delivered by #8) under device-level LOCAL mismatch only (sw_stat_global=0,
* sw_stat_mismatch swept 0/1 by the run script -- see run_mc_untrimmed.py),
* using the SAME Monte Carlo control-loop pattern
* sim/device-pnp-mismatch/testbench/tb_pnp_mismatch.spice and
* sim/device-mos-mismatch/testbench/tb_mos_mismatch.spice already established
* (setseed + dowhile/reset/op, since ngspice re-draws agauss() expressions
* that live inside a subcircuit body -- or, for the resistors here, inside an
* instance-line parameter expression -- on `reset`, giving a genuine Monte
* Carlo rather than N identical samples).
*
* DUT as a swappable include: `shim.spice` and `dut.spice` are generated by
* run_mc_untrimmed.py into the ngspice working directory immediately before
* each invocation (the same "corner shim" pattern sim/tools/devchar.py uses
* for the device-level testbenches). `dut.spice` is a run-script-controlled
* copy of whatever DUT netlist --dut points at (design/netlist/bandgap_top.spice
* by default), so pointing the run script at #17's future extracted netlist
* re-runs this exact fragment unmodified -- no bench edit needed.
*
* `shim.spice` supplies: `.include design.ngspice`, one `.lib` per gf180mcu
* device-family section (MOS/res/BJT/diode/moscap/mimcap, all `typical` --
* this is a mismatch-only claim; global process variation is #12's job, see
* the record's Corner matrix run field for the full justification), `.temp`,
* and `.param sw_stat_mismatch = <0|1>` for this run's group (see GROUPS in
* run_mc_untrimmed.py).
*
* `dut.spice` is either the DUT netlist verbatim (its trailing `.end` is
* stripped by the run script, since an `.include`d `.end` would truncate the
* rest of this deck) or the same netlist with each matched `ppolyf_u`
* resistor instance's `r_length=` parameterized as
* `r_length={<Lnom>u*(1+agauss(0,<sigma>,1))}` -- the resistor-mismatch
* injection this experiment adds (see run_mc_untrimmed.py's `inject_resistor_mismatch`
* docstring for the sigma derivation and its source citation). This
* geometry-parameterization route was chosen over gf180mcu's own per-instance
* `mis_r` resistor-mismatch hook (present in every poly-resistor `.subckt` in
* sm141064.ngspice, e.g. `ppolyf_u`'s `rb` device carries
* `(1+mis_r*sw_stat_mismatch)`, but ships with `mis_r=0` disabled by
* default -- see the friction-protocol note in the record) precisely because
* `mis_r` is gated by the SAME global `sw_stat_mismatch` switch as the MOS
* (`fets_mm`) and BJT (`bjt_mc`) mismatch wrappers: it cannot be turned on
* independently of them, which the sensitivity-breakdown groups below need.
* Geometry parameterization has no such dependency.
*
* The DUT's flattened top netlist uses literal (unwrapped) node names --
* `vdd`, `vss`, `sns1`, `sns2`, `fb`, `vref`, `ibias` -- rather than a
* `bandgap_top` subcircuit (xschem's top-sheet netlister flattens the top
* level instead of emitting a subckt; contrast
* sim/bandgap-loop-smoke/testbench/bandgap_loop_smoke.spice, which manually
* re-wraps the same content in its own `.subckt bandgap_top` before
* instantiating it). This bench uses the flattened form directly and so
* references top-level nodes without an instance prefix (`v(vref)`, not
* `v(xtop.vref)`); the one internal node this bench probes,
* `casc` (the wide-swing cascode bias node), lives inside `bandgap_core`'s
* `.subckt` body and is reached at `xx1.casc`, mirroring
* bandgap_loop_smoke.spice's `xtop.xx1.casc`.
*
* `vss` is a literal net name here (not the reserved ground node `0`), same
* as design/netlist/bandgap_top.spice always required -- bandgap_loop_smoke.spice
* ties it to `0` implicitly via its `bandgap_top` subckt's pin mapping
* (`Xtop vdd 0 vref bandgap_top`); this flattened bench ties it explicitly
* with an ideal 0V source instead.
*
* No startup circuit exists yet (#11): this self-biased loop has both the
* intended nonzero-current operating point and a low/near-zero-current
* degenerate equilibrium (see design/bandgap_operating_point.md and
* sim/bandgap-loop-smoke/testbench/bandgap_loop_smoke.spice, which this
* bench's `.ic` line is copied from verbatim, minus the `xtop.` instance
* prefix bandgap_loop_smoke.spice's re-wrap needed). `.ic` only seeds the DC
* operating-point solver's initial guess -- it is a convergence aid, not a
* startup-behavior claim, and it does not prevent a genuinely
* mismatch-driven degenerate sample from landing there; the run script
* checks every sample's supply current against a degenerate-state threshold
* per #13's acceptance criteria (see `run_mc_untrimmed.py`).
*
* Run via: sim/mc-untrimmed/run_mc_untrimmed.py

.include shim.spice
.include dut.spice

vsup vdd 0 dc 3.30
vssref vss 0 dc 0
.ic v(fb)=1.0 v(sns1)=0.6 v(sns2)=0.6 v(vref)=1.2 v(ibias)=0.6 v(xx1.casc)=1.8

.control
setseed 20260801
set width  = 512
set height = 100000
let mc_runs = 300
let run = 0
dowhile run < mc_runs
  reset
  op
  let vref_val = v(vref)
  let ibias_val = v(ibias)
  let isup_val = -i(vsup)
  print vref_val ibias_val isup_val
  let run = run + 1
end
quit
.endc

.end
