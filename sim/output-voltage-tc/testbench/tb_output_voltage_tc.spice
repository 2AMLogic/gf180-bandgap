* output-voltage-tc -- Vref accuracy and box-method temperature coefficient
*
* Netlist FRAGMENT for sim/harness (see sim/harness/README.md). The harness
* supplies the gf180mcu models, the corner .lib sections, .temp, the
* .control block and .end, and hands this file vdd_val / vdd_nom / temp_c.
* The DUT is NOT defined here: it is .include-d from the manifest's "dut"
* key (sim/dut/bandgap_top.spice by default), so this same testbench re-runs
* unedited against a frozen or post-layout extracted netlist with
* `--dut <path>` -- see sim/dut/README.md.
*
* Claims two rows of README.md's ratified target-spec table:
*
*   1. Output reference 1.20 V +/-2% untrimmed -- the *corner* portion of
*      that row. `vref` is the operating point at this PVT point, i.e. at
*      the harness's own temperature/supply/process axes. The row's 3-sigma
*      mismatch-MC portion is #13's Monte Carlo bench, not this one; a
*      passing record here is necessary, not sufficient, for that row.
*
*   2. Temp coefficient < 50 ppm/degC by the BOX method. The box is taken
*      over an internal `dc temp -40 125 1` sweep (1 degC steps, 166 points)
*      run at every process/supply point, NOT over the harness's three-point
*      temperature axis:
*
*        TC = (Vref_max - Vref_min) / (Vref_27C * 165 degC) * 1e6  [ppm/degC]
*
*      A bandgap's Vref(T) is parabolic; an endpoint-only (3-point)
*      evaluation misses the curvature peak whenever the peak falls between
*      -40, 27 and 125 degC, and reports a TC lower than the part actually
*      has. The fine sweep is what makes the recorded number honest. The
*      three endpoint values are measured too (vref_m40 / vref_27 /
*      vref_125) so the record itself shows what a 3-point evaluation would
*      have claimed at each corner; sim/run_suite.py reports the difference.
*
* Note on redundancy: the box figures (tc_ppm, vref_box_*, vref_m40/27/125)
* are computed inside one ngspice invocation and therefore repeat
* identically across the harness's outer temperature axis at a given
* process/supply point. Only `vref` varies along that axis. This is
* deliberate -- the outer axis is what makes the accuracy claim a full-PVT
* claim, and the record's per-corner table is read column by column.

vsup vdd 0 dc {vdd_val}
Xdut vdd 0 vref bandgap_top

* Seed the DC solver toward the intended (nonzero-current) equilibrium.
* Per design/bandgap_operating_point.md 4.2 this self-biased loop also has a
* degenerate near-zero-current solution and no startup circuit exists yet
* (#11); seeding is a convergence aid for THIS measurement, not evidence of
* self-starting behavior -- that claim belongs to #11's transient bench.
* A corner that collapsed into the degenerate state anyway shows up as a
* vref far outside the accuracy window rather than as a suspiciously
* excellent TC, because both are checked.
.ic v(xdut.fb)=1.0 v(xdut.sns1)=0.6 v(xdut.sns2)=0.6 v(vref)=1.2
+ v(xdut.ibias)=0.6 v(xdut.xx1.casc)=1.8
