* FROZEN DUT netlist -- pinned copy, do not edit or regenerate in place.
*
* Pins the ERROR AMPLIFIER as issue #10 left it: the 5-transistor
* single-stage OTA (NMOS pair W=100u nf=2 / L=4u, uncascoded PMOS mirror
* load W=40u / L=4u, NMOS tail), whose recorded PSRR and untrimmed-accuracy
* shortfalls are what issue #42 exists to close
* (design/bandgap_error_budget.md Sec 5, as #10 wrote it).
*
* Why it exists: #42 rewrote the three amp-* testbenches (current 8-pin
* bandgap_core, bandgap_startup instantiated, .nodeset instead of a .ic
* that ngspice's DC solve ignores), so #10's own records are no longer
* byte-comparable with #42's. Passing
*   --dut sim/dut/frozen/bandgap_amp-20260801-issue10.spice
* re-runs the NEW testbench against the OLD amp, which is what makes the
* before/after deltas quoted in design/bandgap_error_budget.md evidence
* rather than assertion. Superseding a frozen file means adding a new one,
* never editing this one.
*
* Content below is sim/tools/mk_dut.py's conversion of
* design/netlist/bandgap_amp.spice at commit da3a572 (the last commit
* before #42); only this header differs.
*

** sch_path: /Users/rwalters/GitHub/gf180-bandgap/.loom/worktrees/issue-10/design/bandgap_amp.sch
.subckt bandgap_amp in_p in_n vss out vdd tail_bias

*.iopin vdd
*.iopin vss
*.iopin in_p
*.iopin in_n
*.iopin out
*.iopin tail_bias
XM1 nd1 in_p tail vss nfet_03v3 L=4u W=100u nf=2 ad='int((nf+1)/2) * W/nf * 0.18u' as='int((nf+2)/2) * W/nf * 0.18u' pd='2*int((nf+1)/2) * (W/nf + 0.18u)'
+ ps='2*int((nf+2)/2) * (W/nf + 0.18u)' nrd='0.18u / W' nrs='0.18u / W' sa=0 sb=0 sd=0 m=1
XM2 out in_n tail vss nfet_03v3 L=4u W=100u nf=2 ad='int((nf+1)/2) * W/nf * 0.18u' as='int((nf+2)/2) * W/nf * 0.18u' pd='2*int((nf+1)/2) * (W/nf + 0.18u)'
+ ps='2*int((nf+2)/2) * (W/nf + 0.18u)' nrd='0.18u / W' nrs='0.18u / W' sa=0 sb=0 sd=0 m=1
XM3 nd1 nd1 vdd vdd pfet_03v3 L=4u W=40u nf=1 ad='int((nf+1)/2) * W/nf * 0.18u' as='int((nf+2)/2) * W/nf * 0.18u' pd='2*int((nf+1)/2) * (W/nf + 0.18u)'
+ ps='2*int((nf+2)/2) * (W/nf + 0.18u)' nrd='0.18u / W' nrs='0.18u / W' sa=0 sb=0 sd=0 m=1
XM4 out nd1 vdd vdd pfet_03v3 L=4u W=40u nf=1 ad='int((nf+1)/2) * W/nf * 0.18u' as='int((nf+2)/2) * W/nf * 0.18u' pd='2*int((nf+1)/2) * (W/nf + 0.18u)'
+ ps='2*int((nf+2)/2) * (W/nf + 0.18u)' nrd='0.18u / W' nrs='0.18u / W' sa=0 sb=0 sd=0 m=1
XM5 tail tail_bias vss vss nfet_03v3 L=4u W=10u nf=1 ad='int((nf+1)/2) * W/nf * 0.18u' as='int((nf+2)/2) * W/nf * 0.18u' pd='2*int((nf+1)/2) * (W/nf + 0.18u)'
+ ps='2*int((nf+2)/2) * (W/nf + 0.18u)' nrd='0.18u / W' nrs='0.18u / W' sa=0 sb=0 sd=0 m=1
.ends
