* tb_mos_mismatch.spice -- gf180mcu 3.3 V MOS local-mismatch Monte Carlo
*
* Eight nominally identical, equally biased device pairs. Each pair is two
* diode-connected devices (Vds = Vgs, Vsb = 0) driven by equal ideal current
* sources; the pair's gate-voltage difference is exactly the input-referred
* offset that pair would contribute as a current mirror or as an amplifier
* input pair, which is the number the offset budget (#10) and the circuit-level
* Monte Carlo (#13) need.
*
* Statistical setup: `sw_stat_mismatch = 1` (local/intra-die variation only),
* `sw_stat_global` left at the PDK default of 0. That is the gf180mcu
* convention documented in design.ngspice: mismatch on, global process
* variation off, so the spread reported here is pure matching and does not
* double-count the corner matrix in the sibling device-mos-vth record.
*
* The mismatch parameters live in the `fets_mm` subcircuit wrappers
* (`nfet_03v3` / `pfet_03v3` in sm141064.ngspice), which draw per-instance
* agauss() samples for threshold (`mis_vth`) and current factor (`mis_k`).
* ngspice re-draws them on `reset`, so the control loop below is a genuine
* Monte Carlo; `setseed` makes the run reproducible.
*
* Two bias currents per geometry (1 uA and 10 uA) because mismatch refers to
* the gate differently in weak and strong inversion.
*
* No supply rail: every DUT is referred to its own source node at ground.
*
* corner.spice is generated by the run script from $PDK_ROOT / $PDK.
*
* Run via: sim/device-mos-mismatch/run_mos_mismatch.py

.include corner.spice

* Local mismatch on, global process variation off (see header).
.param sw_stat_mismatch = 1

* ---- nfet_03v3 W/L = 10/1, 1 uA ----
In1a 0 gn1a 1u
XN1a gn1a gn1a 0 0 nfet_03v3 w=10u l=1u
In1b 0 gn1b 1u
XN1b gn1b gn1b 0 0 nfet_03v3 w=10u l=1u

* ---- nfet_03v3 W/L = 10/4, 1 uA ----
In4a 0 gn4a 1u
XN4a gn4a gn4a 0 0 nfet_03v3 w=10u l=4u
In4b 0 gn4b 1u
XN4b gn4b gn4b 0 0 nfet_03v3 w=10u l=4u

* ---- pfet_03v3 W/L = 10/1, 1 uA ----
Ip1a gp1a 0 1u
XP1a gp1a gp1a 0 0 pfet_03v3 w=10u l=1u
Ip1b gp1b 0 1u
XP1b gp1b gp1b 0 0 pfet_03v3 w=10u l=1u

* ---- pfet_03v3 W/L = 10/4, 1 uA ----
Ip4a gp4a 0 1u
XP4a gp4a gp4a 0 0 pfet_03v3 w=10u l=4u
Ip4b gp4b 0 1u
XP4b gp4b gp4b 0 0 pfet_03v3 w=10u l=4u

* ---- nfet_03v3 W/L = 10/1, 10 uA ----
Ih1a 0 hn1a 10u
XH1a hn1a hn1a 0 0 nfet_03v3 w=10u l=1u
Ih1b 0 hn1b 10u
XH1b hn1b hn1b 0 0 nfet_03v3 w=10u l=1u

* ---- nfet_03v3 W/L = 10/4, 10 uA ----
Ih4a 0 hn4a 10u
XH4a hn4a hn4a 0 0 nfet_03v3 w=10u l=4u
Ih4b 0 hn4b 10u
XH4b hn4b hn4b 0 0 nfet_03v3 w=10u l=4u

* ---- pfet_03v3 W/L = 10/1, 10 uA ----
Iq1a hp1a 0 10u
XQ1a hp1a hp1a 0 0 pfet_03v3 w=10u l=1u
Iq1b hp1b 0 10u
XQ1b hp1b hp1b 0 0 pfet_03v3 w=10u l=1u

* ---- pfet_03v3 W/L = 10/4, 10 uA ----
Iq4a hp4a 0 10u
XQ4a hp4a hp4a 0 0 pfet_03v3 w=10u l=4u
Iq4b hp4b 0 10u
XQ4b hp4b hp4b 0 0 pfet_03v3 w=10u l=4u

.control
setseed 20260731
set width  = 512
set height = 100000
let mc_runs = 300
let run = 0
dowhile run < mc_runs
  reset
  op
  let dn1 = v(gn1a) - v(gn1b)
  let dn4 = v(gn4a) - v(gn4b)
  let dp1 = v(gp1a) - v(gp1b)
  let dp4 = v(gp4a) - v(gp4b)
  let en1 = v(hn1a) - v(hn1b)
  let en4 = v(hn4a) - v(hn4b)
  let ep1 = v(hp1a) - v(hp1b)
  let ep4 = v(hp4a) - v(hp4b)
  print dn1 dn4 dp1 dp4 en1 en4 ep1 ep4
  let run = run + 1
end
quit
.endc

.end
