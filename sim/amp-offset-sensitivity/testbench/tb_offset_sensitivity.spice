* amp-offset-sensitivity -- dVref/dVos verification
*
* CORE RESIZED IN #61 -- RECORDS TAKEN BEFORE AND AFTER ARE NOT COMPARABLE.
* The bandgap_core copy embedded below carries #61's R1/R2 co-scaling: both
* the PTAT resistor R2 and the output-branch summing resistor R1 (here in
* its pre-trim lumped form, electrically R1 + 32 trim units at the default
* code) are scaled by k = 2, halving the design current I = dVBE/R2 while
* holding I*R1 and the R1/R2 ratio fixed. See design/bandgap_core.sch's
* header and design/bandgap_error_budget.md Sec 5 for the derivation.
*
* Issue #10 created this bench; issue #42 re-ran it against the
* telescopic-cascode amp. dVref/dVos is a property of bandgap_core's
* Brokaw gain, not of the amp, so this re-run is a check that the amp
* redesign did NOT move it -- the offset budget in
* design/bandgap_error_budget.md Sec 2 multiplies the amp's own
* input-referred sigma by exactly this number.
*
* Netlist FRAGMENT for sim/harness (sim/README.md format). The harness
* supplies .include of the gf180mcu models, the corner .lib sections,
* .temp, the .control block and .end. Parameters available: vdd_val,
* vdd_nom, temp_c.
*
* Content below is design/netlist/bandgap_core.spice and
* design/netlist/bandgap_startup.spice, stripped of xschem comment lines
* and re-wrapped as .subckt/.ends, followed by this experiment's own
* stimulus. bandgap_amp is NOT defined here: it comes from the DUT netlist
* the manifest names (sim/dut/bandgap_amp.spice, generated from
* design/netlist/bandgap_amp.spice), which is what lets this same bench be
* re-run unedited against #10's amp with
*   --dut sim/dut/frozen/bandgap_amp-20260801-issue10.spice
* The record's Netlist provenance field then names the exact amp measured,
* by path and sha256 -- see sim/dut/README.md.
*
* TESTBENCH CHANGED IN #42 -- NOT BYTE-COMPARABLE WITH #10's RECORDS.
* #10 minted its records against a pre-#11 copy of bandgap_core (7 pins,
* no `casc` port) with NO bandgap_startup instance, seeding the intended
* operating point with .ic. Two things forced a change here:
*   1. `.ic` is not honoured by ngspice's .op/.ac DC solve (only by
*      transient), so #10's seed was doing nothing at all -- the DC solver
*      simply happened to land on the intended solution for that amp. It
*      does not for every amp, and a testbench whose result depends on
*      which of two physical DC solutions the solver picks is not evidence.
*   2. bandgap_top now instantiates bandgap_startup (#11) and the 8-pin
*      core, so the #10 fragment no longer described the shipping block.
* Instantiating bandgap_startup removes the degenerate solution physically
* (the kick devices hold `fb`/`casc` down until `ibias` is real), so the
* operating point this bench linearises around is the one the block
* actually has. The `.nodeset` below is a solver hint only; the answer no
* longer depends on it.
*
* For a like-for-like comparison, the paired record in this experiment's
* records/ directory was minted from this same testbench with
* --dut sim/dut/frozen/bandgap_amp-20260801-issue10.spice, i.e. #10's 5T
* OTA measured on #42's bench.
*
* METHOD (unchanged from #10): a series test-offset source is inserted
* directly in the amp's in_n path (between the core's sns1 node and the
* amp's in_n pin), so a swept DC voltage there is electrically identical
* to an amp input-referred offset. A 2-point .dc sweep (-2mV, +2mV, well
* inside the diff pair's linear range) gives
* dVref/dVos = (vref(+2mV) - vref(-2mV)) / 4mV from the two op-point
* solutions, with no regression needed.
*

.subckt bandgap_core vdd sns1 sns2 vss fb vref ibias casc

XM1 d1 fb vdd vdd pfet_03v3 L=6u W=60u nf=1 ad='int((nf+1)/2) * W/nf * 0.18u' as='int((nf+2)/2) * W/nf * 0.18u' pd='2*int((nf+1)/2) * (W/nf + 0.18u)'
+ ps='2*int((nf+2)/2) * (W/nf + 0.18u)' nrd='0.18u / W' nrs='0.18u / W' sa=0 sb=0 sd=0 m=1
XMC1 sns1 casc d1 vdd pfet_03v3 L=6u W=60u nf=1 ad='int((nf+1)/2) * W/nf * 0.18u' as='int((nf+2)/2) * W/nf * 0.18u' pd='2*int((nf+1)/2) * (W/nf + 0.18u)'
+ ps='2*int((nf+2)/2) * (W/nf + 0.18u)' nrd='0.18u / W' nrs='0.18u / W' sa=0 sb=0 sd=0 m=1
XQ1 vss vss sns1 pnp_05p00x05p00 m=1
XM2 d2 fb vdd vdd pfet_03v3 L=6u W=60u nf=1 ad='int((nf+1)/2) * W/nf * 0.18u' as='int((nf+2)/2) * W/nf * 0.18u' pd='2*int((nf+1)/2) * (W/nf + 0.18u)'
+ ps='2*int((nf+2)/2) * (W/nf + 0.18u)' nrd='0.18u / W' nrs='0.18u / W' sa=0 sb=0 sd=0 m=1
XMC2 sns2 casc d2 vdd pfet_03v3 L=6u W=60u nf=1 ad='int((nf+1)/2) * W/nf * 0.18u' as='int((nf+2)/2) * W/nf * 0.18u' pd='2*int((nf+1)/2) * (W/nf + 0.18u)'
+ ps='2*int((nf+2)/2) * (W/nf + 0.18u)' nrd='0.18u / W' nrs='0.18u / W' sa=0 sb=0 sd=0 m=1
XR2 e2 sns2 vss ppolyf_u r_width=2u r_length=36.341871u m=1
XQ2 vss vss e2 pnp_10p00x10p00 m=1
XM3 d3 fb vdd vdd pfet_03v3 L=6u W=60u nf=1 ad='int((nf+1)/2) * W/nf * 0.18u' as='int((nf+2)/2) * W/nf * 0.18u' pd='2*int((nf+1)/2) * (W/nf + 0.18u)'
+ ps='2*int((nf+2)/2) * (W/nf + 0.18u)' nrd='0.18u / W' nrs='0.18u / W' sa=0 sb=0 sd=0 m=1
XMC3 vref casc d3 vdd pfet_03v3 L=6u W=60u nf=1 ad='int((nf+1)/2) * W/nf * 0.18u' as='int((nf+2)/2) * W/nf * 0.18u' pd='2*int((nf+1)/2) * (W/nf + 0.18u)'
+ ps='2*int((nf+2)/2) * (W/nf + 0.18u)' nrd='0.18u / W' nrs='0.18u / W' sa=0 sb=0 sd=0 m=1
XR1 e3 vref vss ppolyf_u r_width=2u r_length=560.341647u m=1
XQ3 vss vss e3 pnp_05p00x05p00 m=1
XM4 d4 fb vdd vdd pfet_03v3 L=6u W=7.5u nf=1 ad='int((nf+1)/2) * W/nf * 0.18u' as='int((nf+2)/2) * W/nf * 0.18u' pd='2*int((nf+1)/2) * (W/nf + 0.18u)'
+ ps='2*int((nf+2)/2) * (W/nf + 0.18u)' nrd='0.18u / W' nrs='0.18u / W' sa=0 sb=0 sd=0 m=1
XMC4 ibias casc d4 vdd pfet_03v3 L=6u W=7.5u nf=1 ad='int((nf+1)/2) * W/nf * 0.18u' as='int((nf+2)/2) * W/nf * 0.18u' pd='2*int((nf+1)/2) * (W/nf + 0.18u)'
+ ps='2*int((nf+2)/2) * (W/nf + 0.18u)' nrd='0.18u / W' nrs='0.18u / W' sa=0 sb=0 sd=0 m=1
XM5 ibias ibias vss vss nfet_03v3 L=2u W=2.5u nf=1 ad='int((nf+1)/2) * W/nf * 0.18u' as='int((nf+2)/2) * W/nf * 0.18u' pd='2*int((nf+1)/2) * (W/nf + 0.18u)'
+ ps='2*int((nf+2)/2) * (W/nf + 0.18u)' nrd='0.18u / W' nrs='0.18u / W' sa=0 sb=0 sd=0 m=1
XMCB casc casc vdd vdd pfet_03v3 L=12u W=4u nf=1 ad='int((nf+1)/2) * W/nf * 0.18u' as='int((nf+2)/2) * W/nf * 0.18u' pd='2*int((nf+1)/2) * (W/nf + 0.18u)'
+ ps='2*int((nf+2)/2) * (W/nf + 0.18u)' nrd='0.18u / W' nrs='0.18u / W' sa=0 sb=0 sd=0 m=1
XMNB casc ibias vss vss nfet_03v3 L=2u W=5u nf=1 ad='int((nf+1)/2) * W/nf * 0.18u' as='int((nf+2)/2) * W/nf * 0.18u' pd='2*int((nf+1)/2) * (W/nf + 0.18u)'
+ ps='2*int((nf+2)/2) * (W/nf + 0.18u)' nrd='0.18u / W' nrs='0.18u / W' sa=0 sb=0 sd=0 m=1
.ends

.subckt bandgap_startup vdd vss fb casc ibias

XMSENSE det ibias vss vss nfet_03v3 L=2u W=20u nf=1 ad='int((nf+1)/2) * W/nf * 0.18u' as='int((nf+2)/2) * W/nf * 0.18u' pd='2*int((nf+1)/2) * (W/nf + 0.18u)'
+ ps='2*int((nf+2)/2) * (W/nf + 0.18u)' nrd='0.18u / W' nrs='0.18u / W' sa=0 sb=0 sd=0 m=1
XRPU det vdd vss ppolyf_u_1k r_width=2u r_length=4000u m=1
XMKFB fb det vss vss nfet_03v3 L=2u W=2u nf=1 ad='int((nf+1)/2) * W/nf * 0.18u' as='int((nf+2)/2) * W/nf * 0.18u' pd='2*int((nf+1)/2) * (W/nf + 0.18u)'
+ ps='2*int((nf+2)/2) * (W/nf + 0.18u)' nrd='0.18u / W' nrs='0.18u / W' sa=0 sb=0 sd=0 m=1
XMKCASC casc det vss vss nfet_03v3 L=2u W=2u nf=1 ad='int((nf+1)/2) * W/nf * 0.18u' as='int((nf+2)/2) * W/nf * 0.18u' pd='2*int((nf+1)/2) * (W/nf + 0.18u)'
+ ps='2*int((nf+2)/2) * (W/nf + 0.18u)' nrd='0.18u / W' nrs='0.18u / W' sa=0 sb=0 sd=0 m=1
.ends

vsup vdd 0 dc {vdd_val}
Xcore vdd sns1 sns2 0 fb vref ibias casc bandgap_core
Xamp sns2 vos_node 0 fb vdd ibias bandgap_amp
Xstart vdd 0 fb casc ibias bandgap_startup
vos vos_node sns1 dc 0

.nodeset v(fb)=2.27 v(sns1)=0.72 v(sns2)=0.72 v(vref)=1.23 v(ibias)=0.75
+ v(casc)=1.75
