* Frozen netlist snapshot for record 20260801-231346-960f726
* source     : sim/trim-coverage/testbench/tb_trim_coverage.spice
* sha256     : 4e2219c85d7d57d3a1359c07a75f4fe859e211d33c7c4737251e30a3af38a8f9
* This is a verbatim copy taken at record time. Do not edit.
* trim-coverage -- binary-weighted trim ladder range, resolution and
* linearity on bandgap_top, over the full PVT grid (issue #14)
*
* Netlist FRAGMENT for sim/harness (see sim/harness/README.md). The harness
* supplies the gf180mcu models, the corner .lib sections, .temp, the
* .control block and .end, and hands this file vdd_val / vdd_nom / temp_c.
* The DUT is .include-d from the manifest's "dut" key
* (sim/dut/bandgap_top.spice), so this bench re-runs unedited against a
* frozen or post-layout extracted netlist via `--dut` -- see
* sim/dut/README.md.
*
* Claim: README.md's ratified Trim row -- "1-point resistor trim
* (binary-weighted segments per DR-0001), range >= +/-5%, resolution
* <= 0.25%/step (>=5 bits equiv.), magnitude only", performed at 27 C.
* Sizing derivation and the coverage argument against the untrimmed
* mismatch spread: design/bandgap_trim_network.md.
*
* HOW THE SWEEP WORKS. design/bandgap_trim.sch carries the ladder as 63
* IDENTICAL ppolyf_u unit segments in one series string, tapped into six
* groups of 1/2/4/8/16/32 units, each group shunted by a strap RS0..RS5
* whose value is decoded from the subcircuit-local parameter `trim_code`
* (0..63, default 32). The manifest's "analyses" block walks a set of codes
* with
*   alterparam bandgap_trim trim_code = <n>
*   reset
*   op
* and stores v(vref) per code into the vector `vv`. `alterparam` + `reset` is
* used rather than 64 separate decks because the ladder is a pure series
* string in the output branch: vref = VEB(Q3) + I*(R1 + Rtrim) and the PTAT
* current I = dVBE/R2 is fixed by the R2/Q1/Q2 loop, independent of what sits
* in the output branch. vref is therefore EXACTLY linear in the selected
* segment resistance, so the seven measured points {code 0, and the six
* single-group codes 1, 2, 4, 8, 16, 32} determine all 64 codes by
* superposition. The bench does not assume that: it measures full scale
* (code 63) too and reports the superposition residual `lin_resid_mv`, which
* is the linearity claim rather than an assumption behind it.
*
* Codes visited, in order, and their index in `vv`:
*   0 -> vv[0]   1 -> vv[1]   2 -> vv[2]   4 -> vv[3]   8 -> vv[4]
*  16 -> vv[5]  32 -> vv[6]  63 -> vv[7]  22 -> vv[8]
* Code 32 is the schematic default (MSB group only), which reproduces the
* pre-trim drawn 280 um summing resistor. Code 22 is the code that lands
* nearest 1.200 V at tt/27 C on the nominal (mismatch-free) design -- i.e.
* the code a 1-point trim would pick for a typical die -- carried across the
* whole grid so the record can report trimmed accuracy over PVT, not just at
* the trim temperature.

vsup vdd 0 dc {vdd_val}
Xdut vdd 0 vref bandgap_top

* Seed the DC solver toward the intended (nonzero-current) equilibrium, the
* same convergence aid every other bandgap_top bench uses. bandgap_startup
* (#11) makes the intended state reachable without seeding; the seed is here
* so that a `reset` in the middle of a code sweep restarts from the same
* place every time rather than from whatever the previous code left behind.
.ic v(xdut.fb)=1.0 v(xdut.sns1)=0.6 v(xdut.sns2)=0.6 v(vref)=1.2
+ v(xdut.ibias)=0.6 v(xdut.xx1.casc)=1.8

* ---------------------------------------------------------------
* DUT netlist included by this testbench (schematic)
* source     : sim/dut/bandgap_top.spice
* sha256     : 46b473ccbd9f825b4720c237b7bb728fc85ad12082bdc59a263862dd363a4852
* ---------------------------------------------------------------

* DUT netlist fragment -- GENERATED, do not edit by hand.
*
* source     : design/netlist/bandgap_top.spice
* sha256     : 1765d65efda4eed23497e138adf827ed1833846228468638ef0f211ee869e14f
* regenerate : python3 sim/tools/mk_dut.py design/netlist/bandgap_top.spice <this file>
*
* Subcircuits defined here: bandgap_top, bandgap_core, bandgap_amp, bandgap_startup, bandgap_trim
*
* Included by the corner runner ahead of each testbench (tb.json's
* "dut" key, or --dut). Holds subcircuit definitions only: no .end,
* .control, .temp or .lib -- the harness owns those per PVT point.

** sch_path: /Users/rwalters/GitHub/gf180-bandgap/.loom/worktrees/issue-61/design/bandgap_top.sch
.subckt bandgap_top vdd vss vref

*.iopin vdd
*.iopin vss
*.iopin vref
Xx1 vdd sns1 sns2 vss fb vref ibias casc bandgap_core
Xx2 sns2 sns1 vss fb vdd ibias bandgap_amp
Xx3 vdd vss fb casc ibias bandgap_startup
.ends

* expanding   symbol:  bandgap_core.sym # of pins=8
** sym_path: /Users/rwalters/GitHub/gf180-bandgap/.loom/worktrees/issue-61/design/bandgap_core.sym
** sch_path: /Users/rwalters/GitHub/gf180-bandgap/.loom/worktrees/issue-61/design/bandgap_core.sch
.subckt bandgap_core vdd sns1 sns2 vss fb vref ibias casc

*.iopin vdd
*.iopin vss
*.iopin fb
*.iopin sns1
*.iopin sns2
*.iopin vref
*.iopin ibias
*.iopin casc
XM1 d1 fb vdd vdd pfet_03v3 L=6u W=60u nf=1 ad='int((nf+1)/2) * W/nf * 0.18u' as='int((nf+2)/2) * W/nf * 0.18u' pd='2*int((nf+1)/2) * (W/nf + 0.18u)'
+ ps='2*int((nf+2)/2) * (W/nf + 0.18u)' nrd='0.18u / W' nrs='0.18u / W' sa=0 sb=0 sd=0 m=1
XMC1 sns1 casc d1 vdd pfet_03v3 L=6u W=60u nf=1 ad='int((nf+1)/2) * W/nf * 0.18u' as='int((nf+2)/2) * W/nf * 0.18u' pd='2*int((nf+1)/2) * (W/nf + 0.18u)'
+ ps='2*int((nf+2)/2) * (W/nf + 0.18u)' nrd='0.18u / W' nrs='0.18u / W' sa=0 sb=0 sd=0 m=1
XQ1 vss vss sns1 pnp_05p00x05p00 m=1
XM2 d2 fb vdd vdd pfet_03v3 L=6u W=60u nf=1 ad='int((nf+1)/2) * W/nf * 0.18u' as='int((nf+2)/2) * W/nf * 0.18u' pd='2*int((nf+1)/2) * (W/nf + 0.18u)'
+ ps='2*int((nf+2)/2) * (W/nf + 0.18u)' nrd='0.18u / W' nrs='0.18u / W' sa=0 sb=0 sd=0 m=1
XMC2 sns2 casc d2 vdd pfet_03v3 L=6u W=60u nf=1 ad='int((nf+1)/2) * W/nf * 0.18u' as='int((nf+2)/2) * W/nf * 0.18u' pd='2*int((nf+1)/2) * (W/nf + 0.18u)'
+ ps='2*int((nf+2)/2) * (W/nf + 0.18u)' nrd='0.18u / W' nrs='0.18u / W' sa=0 sb=0 sd=0 m=1
XR2 e2 sns2 vss ppolyf_u r_width=2u r_length=36.341871u m=1
XQ2 vss vss e2 pnp_10p00x10p00 m=1
XM3 d3 fb vdd vdd pfet_03v3 L=6u W=60u nf=1 ad='int((nf+1)/2) * W/nf * 0.18u' as='int((nf+2)/2) * W/nf * 0.18u' pd='2*int((nf+1)/2) * (W/nf + 0.18u)'
+ ps='2*int((nf+2)/2) * (W/nf + 0.18u)' nrd='0.18u / W' nrs='0.18u / W' sa=0 sb=0 sd=0 m=1
XMC3 vref casc d3 vdd pfet_03v3 L=6u W=60u nf=1 ad='int((nf+1)/2) * W/nf * 0.18u' as='int((nf+2)/2) * W/nf * 0.18u' pd='2*int((nf+1)/2) * (W/nf + 0.18u)'
+ ps='2*int((nf+2)/2) * (W/nf + 0.18u)' nrd='0.18u / W' nrs='0.18u / W' sa=0 sb=0 sd=0 m=1
XR1 e3 tn0 vss ppolyf_u r_width=2u r_length=460.701871u m=1
XQ3 vss vss e3 pnp_05p00x05p00 m=1
XM4 d4 fb vdd vdd pfet_03v3 L=6u W=7.5u nf=1 ad='int((nf+1)/2) * W/nf * 0.18u' as='int((nf+2)/2) * W/nf * 0.18u' pd='2*int((nf+1)/2) * (W/nf + 0.18u)'
+ ps='2*int((nf+2)/2) * (W/nf + 0.18u)' nrd='0.18u / W' nrs='0.18u / W' sa=0 sb=0 sd=0 m=1
XMC4 ibias casc d4 vdd pfet_03v3 L=6u W=7.5u nf=1 ad='int((nf+1)/2) * W/nf * 0.18u' as='int((nf+2)/2) * W/nf * 0.18u' pd='2*int((nf+1)/2) * (W/nf + 0.18u)'
+ ps='2*int((nf+2)/2) * (W/nf + 0.18u)' nrd='0.18u / W' nrs='0.18u / W' sa=0 sb=0 sd=0 m=1
XM5 ibias ibias vss vss nfet_03v3 L=2u W=2.5u nf=1 ad='int((nf+1)/2) * W/nf * 0.18u' as='int((nf+2)/2) * W/nf * 0.18u' pd='2*int((nf+1)/2) * (W/nf + 0.18u)'
+ ps='2*int((nf+2)/2) * (W/nf + 0.18u)' nrd='0.18u / W' nrs='0.18u / W' sa=0 sb=0 sd=0 m=1
XMCB casc casc vdd vdd pfet_03v3 L=12u W=4u nf=1 ad='int((nf+1)/2) * W/nf * 0.18u' as='int((nf+2)/2) * W/nf * 0.18u' pd='2*int((nf+1)/2) * (W/nf + 0.18u)'
+ ps='2*int((nf+2)/2) * (W/nf + 0.18u)' nrd='0.18u / W' nrs='0.18u / W' sa=0 sb=0 sd=0 m=1
XMNB casc ibias vss vss nfet_03v3 L=2u W=5u nf=1 ad='int((nf+1)/2) * W/nf * 0.18u' as='int((nf+2)/2) * W/nf * 0.18u' pd='2*int((nf+1)/2) * (W/nf + 0.18u)'
+ ps='2*int((nf+2)/2) * (W/nf + 0.18u)' nrd='0.18u / W' nrs='0.18u / W' sa=0 sb=0 sd=0 m=1
XXTRIM tn0 vref vss bandgap_trim
.ends

* expanding   symbol:  bandgap_amp.sym # of pins=6
** sym_path: /Users/rwalters/GitHub/gf180-bandgap/.loom/worktrees/issue-61/design/bandgap_amp.sym
** sch_path: /Users/rwalters/GitHub/gf180-bandgap/.loom/worktrees/issue-61/design/bandgap_amp.sch
.subckt bandgap_amp in_p in_n vss out vdd tail_bias

*.iopin vdd
*.iopin vss
*.iopin in_p
*.iopin in_n
*.iopin out
*.iopin tail_bias
XM3 a3 nd1 vdd vdd pfet_03v3 L=16u W=20u nf=1 ad='int((nf+1)/2) * W/nf * 0.18u' as='int((nf+2)/2) * W/nf * 0.18u' pd='2*int((nf+1)/2) * (W/nf + 0.18u)'
+ ps='2*int((nf+2)/2) * (W/nf + 0.18u)' nrd='0.18u / W' nrs='0.18u / W' sa=0 sb=0 sd=0 m=1
XM4 a4 nd1 vdd vdd pfet_03v3 L=16u W=20u nf=1 ad='int((nf+1)/2) * W/nf * 0.18u' as='int((nf+2)/2) * W/nf * 0.18u' pd='2*int((nf+1)/2) * (W/nf + 0.18u)'
+ ps='2*int((nf+2)/2) * (W/nf + 0.18u)' nrd='0.18u / W' nrs='0.18u / W' sa=0 sb=0 sd=0 m=1
XMC3 nd1 pbias a3 vdd pfet_03v3 L=16u W=40u nf=1 ad='int((nf+1)/2) * W/nf * 0.18u' as='int((nf+2)/2) * W/nf * 0.18u' pd='2*int((nf+1)/2) * (W/nf + 0.18u)'
+ ps='2*int((nf+2)/2) * (W/nf + 0.18u)' nrd='0.18u / W' nrs='0.18u / W' sa=0 sb=0 sd=0 m=1
XMC4 out pbias a4 vdd pfet_03v3 L=16u W=40u nf=1 ad='int((nf+1)/2) * W/nf * 0.18u' as='int((nf+2)/2) * W/nf * 0.18u' pd='2*int((nf+1)/2) * (W/nf + 0.18u)'
+ ps='2*int((nf+2)/2) * (W/nf + 0.18u)' nrd='0.18u / W' nrs='0.18u / W' sa=0 sb=0 sd=0 m=1
XMC1 nd1 ncasc n1 vss nfet_03v3 L=16u W=20u nf=1 ad='int((nf+1)/2) * W/nf * 0.18u' as='int((nf+2)/2) * W/nf * 0.18u' pd='2*int((nf+1)/2) * (W/nf + 0.18u)'
+ ps='2*int((nf+2)/2) * (W/nf + 0.18u)' nrd='0.18u / W' nrs='0.18u / W' sa=0 sb=0 sd=0 m=1
XMC2 out ncasc n2 vss nfet_03v3 L=16u W=20u nf=1 ad='int((nf+1)/2) * W/nf * 0.18u' as='int((nf+2)/2) * W/nf * 0.18u' pd='2*int((nf+1)/2) * (W/nf + 0.18u)'
+ ps='2*int((nf+2)/2) * (W/nf + 0.18u)' nrd='0.18u / W' nrs='0.18u / W' sa=0 sb=0 sd=0 m=1
XM1 n1 in_p tail vss nfet_03v3 L=4u W=200u nf=4 ad='int((nf+1)/2) * W/nf * 0.18u' as='int((nf+2)/2) * W/nf * 0.18u' pd='2*int((nf+1)/2) * (W/nf + 0.18u)'
+ ps='2*int((nf+2)/2) * (W/nf + 0.18u)' nrd='0.18u / W' nrs='0.18u / W' sa=0 sb=0 sd=0 m=1
XM2 n2 in_n tail vss nfet_03v3 L=4u W=200u nf=4 ad='int((nf+1)/2) * W/nf * 0.18u' as='int((nf+2)/2) * W/nf * 0.18u' pd='2*int((nf+1)/2) * (W/nf + 0.18u)'
+ ps='2*int((nf+2)/2) * (W/nf + 0.18u)' nrd='0.18u / W' nrs='0.18u / W' sa=0 sb=0 sd=0 m=1
XM5 tail tail_bias vss vss nfet_03v3 L=4u W=10u nf=1 ad='int((nf+1)/2) * W/nf * 0.18u' as='int((nf+2)/2) * W/nf * 0.18u' pd='2*int((nf+1)/2) * (W/nf + 0.18u)'
+ ps='2*int((nf+2)/2) * (W/nf + 0.18u)' nrd='0.18u / W' nrs='0.18u / W' sa=0 sb=0 sd=0 m=1
XMBN2 pbias tail_bias vss vss nfet_03v3 L=16u W=2u nf=1 ad='int((nf+1)/2) * W/nf * 0.18u' as='int((nf+2)/2) * W/nf * 0.18u' pd='2*int((nf+1)/2) * (W/nf + 0.18u)'
+ ps='2*int((nf+2)/2) * (W/nf + 0.18u)' nrd='0.18u / W' nrs='0.18u / W' sa=0 sb=0 sd=0 m=1
XMBP1 pbias pbias vdd vdd pfet_03v3 L=50u W=1u nf=1 ad='int((nf+1)/2) * W/nf * 0.18u' as='int((nf+2)/2) * W/nf * 0.18u' pd='2*int((nf+1)/2) * (W/nf + 0.18u)'
+ ps='2*int((nf+2)/2) * (W/nf + 0.18u)' nrd='0.18u / W' nrs='0.18u / W' sa=0 sb=0 sd=0 m=1
XMB1 ncasc pbias vdd vdd pfet_03v3 L=50u W=5u nf=1 ad='int((nf+1)/2) * W/nf * 0.18u' as='int((nf+2)/2) * W/nf * 0.18u' pd='2*int((nf+1)/2) * (W/nf + 0.18u)'
+ ps='2*int((nf+2)/2) * (W/nf + 0.18u)' nrd='0.18u / W' nrs='0.18u / W' sa=0 sb=0 sd=0 m=1
XMBD1 ncasc ncasc nb1 vss nfet_03v3 L=4u W=1u nf=1 ad='int((nf+1)/2) * W/nf * 0.18u' as='int((nf+2)/2) * W/nf * 0.18u' pd='2*int((nf+1)/2) * (W/nf + 0.18u)'
+ ps='2*int((nf+2)/2) * (W/nf + 0.18u)' nrd='0.18u / W' nrs='0.18u / W' sa=0 sb=0 sd=0 m=1
XMBD2 nb1 nb1 vss vss nfet_03v3 L=4u W=1u nf=1 ad='int((nf+1)/2) * W/nf * 0.18u' as='int((nf+2)/2) * W/nf * 0.18u' pd='2*int((nf+1)/2) * (W/nf + 0.18u)'
+ ps='2*int((nf+2)/2) * (W/nf + 0.18u)' nrd='0.18u / W' nrs='0.18u / W' sa=0 sb=0 sd=0 m=1
XCC vdd out cap_mim_2f0_m4m5_noshield c_width=60u c_length=60u m=1
.ends

* expanding   symbol:  bandgap_startup.sym # of pins=5
** sym_path: /Users/rwalters/GitHub/gf180-bandgap/.loom/worktrees/issue-61/design/bandgap_startup.sym
** sch_path: /Users/rwalters/GitHub/gf180-bandgap/.loom/worktrees/issue-61/design/bandgap_startup.sch
.subckt bandgap_startup vdd vss fb casc ibias

*.iopin vdd
*.iopin vss
*.iopin fb
*.iopin casc
*.iopin ibias
XMSENSE det ibias vss vss nfet_03v3 L=2u W=20u nf=1 ad='int((nf+1)/2) * W/nf * 0.18u' as='int((nf+2)/2) * W/nf * 0.18u' pd='2*int((nf+1)/2) * (W/nf + 0.18u)'
+ ps='2*int((nf+2)/2) * (W/nf + 0.18u)' nrd='0.18u / W' nrs='0.18u / W' sa=0 sb=0 sd=0 m=1
XRPU det vdd vss ppolyf_u_1k r_width=2u r_length=4000u m=1
XMKFB fb det vss vss nfet_03v3 L=2u W=2u nf=1 ad='int((nf+1)/2) * W/nf * 0.18u' as='int((nf+2)/2) * W/nf * 0.18u' pd='2*int((nf+1)/2) * (W/nf + 0.18u)'
+ ps='2*int((nf+2)/2) * (W/nf + 0.18u)' nrd='0.18u / W' nrs='0.18u / W' sa=0 sb=0 sd=0 m=1
XMKCASC casc det vss vss nfet_03v3 L=2u W=2u nf=1 ad='int((nf+1)/2) * W/nf * 0.18u' as='int((nf+2)/2) * W/nf * 0.18u' pd='2*int((nf+1)/2) * (W/nf + 0.18u)'
+ ps='2*int((nf+2)/2) * (W/nf + 0.18u)' nrd='0.18u / W' nrs='0.18u / W' sa=0 sb=0 sd=0 m=1
.ends

* expanding   symbol:  bandgap_trim.sym # of pins=3
** sym_path: /Users/rwalters/GitHub/gf180-bandgap/.loom/worktrees/issue-61/design/bandgap_trim.sym
** sch_path: /Users/rwalters/GitHub/gf180-bandgap/.loom/worktrees/issue-61/design/bandgap_trim.sch
.subckt bandgap_trim bot top sub

*.iopin bot
*.iopin top
*.iopin sub
**** begin user architecture code

.param trim_code=32

**** end user architecture code
XRU0 bot tn1 sub ppolyf_u r_width=2u r_length=2.771871u m=1
RS0 tn1 bot {1e-3 + 1e12*(floor(trim_code/1)-2*floor(trim_code/2))} m=1
XRU1 tn1 u1_0 sub ppolyf_u r_width=2u r_length=2.771871u m=1
XRU2 u1_0 tn2 sub ppolyf_u r_width=2u r_length=2.771871u m=1
RS1 tn2 tn1 {1e-3 + 1e12*(floor(trim_code/2)-2*floor(trim_code/4))} m=1
XRU3 tn2 u2_0 sub ppolyf_u r_width=2u r_length=2.771871u m=1
XRU4 u2_0 u2_1 sub ppolyf_u r_width=2u r_length=2.771871u m=1
XRU5 u2_1 u2_2 sub ppolyf_u r_width=2u r_length=2.771871u m=1
XRU6 u2_2 tn3 sub ppolyf_u r_width=2u r_length=2.771871u m=1
RS2 tn3 tn2 {1e-3 + 1e12*(floor(trim_code/4)-2*floor(trim_code/8))} m=1
XRU7 tn3 u3_0 sub ppolyf_u r_width=2u r_length=2.771871u m=1
XRU8 u3_0 u3_1 sub ppolyf_u r_width=2u r_length=2.771871u m=1
XRU9 u3_1 u3_2 sub ppolyf_u r_width=2u r_length=2.771871u m=1
XRU10 u3_2 u3_3 sub ppolyf_u r_width=2u r_length=2.771871u m=1
XRU11 u3_3 u3_4 sub ppolyf_u r_width=2u r_length=2.771871u m=1
XRU12 u3_4 u3_5 sub ppolyf_u r_width=2u r_length=2.771871u m=1
XRU13 u3_5 u3_6 sub ppolyf_u r_width=2u r_length=2.771871u m=1
XRU14 u3_6 tn4 sub ppolyf_u r_width=2u r_length=2.771871u m=1
RS3 tn4 tn3 {1e-3 + 1e12*(floor(trim_code/8)-2*floor(trim_code/16))} m=1
XRU15 tn4 u4_0 sub ppolyf_u r_width=2u r_length=2.771871u m=1
XRU16 u4_0 u4_1 sub ppolyf_u r_width=2u r_length=2.771871u m=1
XRU17 u4_1 u4_2 sub ppolyf_u r_width=2u r_length=2.771871u m=1
XRU18 u4_2 u4_3 sub ppolyf_u r_width=2u r_length=2.771871u m=1
XRU19 u4_3 u4_4 sub ppolyf_u r_width=2u r_length=2.771871u m=1
XRU20 u4_4 u4_5 sub ppolyf_u r_width=2u r_length=2.771871u m=1
XRU21 u4_5 u4_6 sub ppolyf_u r_width=2u r_length=2.771871u m=1
XRU22 u4_6 u4_7 sub ppolyf_u r_width=2u r_length=2.771871u m=1
XRU23 u4_7 u4_8 sub ppolyf_u r_width=2u r_length=2.771871u m=1
XRU24 u4_8 u4_9 sub ppolyf_u r_width=2u r_length=2.771871u m=1
XRU25 u4_9 u4_10 sub ppolyf_u r_width=2u r_length=2.771871u m=1
XRU26 u4_10 u4_11 sub ppolyf_u r_width=2u r_length=2.771871u m=1
XRU27 u4_11 u4_12 sub ppolyf_u r_width=2u r_length=2.771871u m=1
XRU28 u4_12 u4_13 sub ppolyf_u r_width=2u r_length=2.771871u m=1
XRU29 u4_13 u4_14 sub ppolyf_u r_width=2u r_length=2.771871u m=1
XRU30 u4_14 tn5 sub ppolyf_u r_width=2u r_length=2.771871u m=1
RS4 tn5 tn4 {1e-3 + 1e12*(floor(trim_code/16)-2*floor(trim_code/32))} m=1
XRU31 tn5 u5_0 sub ppolyf_u r_width=2u r_length=2.771871u m=1
XRU32 u5_0 u5_1 sub ppolyf_u r_width=2u r_length=2.771871u m=1
XRU33 u5_1 u5_2 sub ppolyf_u r_width=2u r_length=2.771871u m=1
XRU34 u5_2 u5_3 sub ppolyf_u r_width=2u r_length=2.771871u m=1
XRU35 u5_3 u5_4 sub ppolyf_u r_width=2u r_length=2.771871u m=1
XRU36 u5_4 u5_5 sub ppolyf_u r_width=2u r_length=2.771871u m=1
XRU37 u5_5 u5_6 sub ppolyf_u r_width=2u r_length=2.771871u m=1
XRU38 u5_6 u5_7 sub ppolyf_u r_width=2u r_length=2.771871u m=1
XRU39 u5_7 u5_8 sub ppolyf_u r_width=2u r_length=2.771871u m=1
XRU40 u5_8 u5_9 sub ppolyf_u r_width=2u r_length=2.771871u m=1
XRU41 u5_9 u5_10 sub ppolyf_u r_width=2u r_length=2.771871u m=1
XRU42 u5_10 u5_11 sub ppolyf_u r_width=2u r_length=2.771871u m=1
XRU43 u5_11 u5_12 sub ppolyf_u r_width=2u r_length=2.771871u m=1
XRU44 u5_12 u5_13 sub ppolyf_u r_width=2u r_length=2.771871u m=1
XRU45 u5_13 u5_14 sub ppolyf_u r_width=2u r_length=2.771871u m=1
XRU46 u5_14 u5_15 sub ppolyf_u r_width=2u r_length=2.771871u m=1
XRU47 u5_15 u5_16 sub ppolyf_u r_width=2u r_length=2.771871u m=1
XRU48 u5_16 u5_17 sub ppolyf_u r_width=2u r_length=2.771871u m=1
XRU49 u5_17 u5_18 sub ppolyf_u r_width=2u r_length=2.771871u m=1
XRU50 u5_18 u5_19 sub ppolyf_u r_width=2u r_length=2.771871u m=1
XRU51 u5_19 u5_20 sub ppolyf_u r_width=2u r_length=2.771871u m=1
XRU52 u5_20 u5_21 sub ppolyf_u r_width=2u r_length=2.771871u m=1
XRU53 u5_21 u5_22 sub ppolyf_u r_width=2u r_length=2.771871u m=1
XRU54 u5_22 u5_23 sub ppolyf_u r_width=2u r_length=2.771871u m=1
XRU55 u5_23 u5_24 sub ppolyf_u r_width=2u r_length=2.771871u m=1
XRU56 u5_24 u5_25 sub ppolyf_u r_width=2u r_length=2.771871u m=1
XRU57 u5_25 u5_26 sub ppolyf_u r_width=2u r_length=2.771871u m=1
XRU58 u5_26 u5_27 sub ppolyf_u r_width=2u r_length=2.771871u m=1
XRU59 u5_27 u5_28 sub ppolyf_u r_width=2u r_length=2.771871u m=1
XRU60 u5_28 u5_29 sub ppolyf_u r_width=2u r_length=2.771871u m=1
XRU61 u5_29 u5_30 sub ppolyf_u r_width=2u r_length=2.771871u m=1
XRU62 u5_30 top sub ppolyf_u r_width=2u r_length=2.771871u m=1
RS5 top tn5 {1e-3 + 1e12*(floor(trim_code/32)-2*floor(trim_code/64))} m=1
.ends
