* Frozen netlist snapshot for record 20260803-055559-31e5efc
* source     : sim/startup-extracted/testbench/bandgap_startup_ramp_extracted.spice
* sha256     : e185d5717312e5082a71b3648210fad2bc7518a9906066bb1aa0c7a1a0ce0954
* This is a verbatim copy taken at record time. Do not edit.
* bandgap-startup supply-ramp testbench, POST-LAYOUT form (issues #11/#17).
*
* Same experiment as sim/startup/ -- a supply ramp from 0 V into a cold
* block, measuring the time from vdd reaching 90 % of its final value to
* v(vref) settling permanently inside +/-1 % of its own final value -- but
* written against sim/dut's *swappable-DUT* convention instead of carrying
* its own embedded copy of the circuit.
*
* Why a separate slug rather than `run_corners.py startup --dut ...`:
* sim/startup/testbench/bandgap_startup_ramp.spice embeds its own copy of
* bandgap_top/bandgap_core/bandgap_amp/bandgap_startup and declares no
* "dut" key, because it inserts a zero-volt ammeter (Vsu_sense) *between*
* the shared vdd rail and bandgap_startup's own vdd pin -- instrumentation
* that only exists if the startup branch is a separate subcircuit
* instance. Passing --dut to that bench does not swap the circuit; it
* .include's a second, conflicting definition of `bandgap_top` ahead of
* the bench's own, and the run dies on the now-dangling
* `v.xtop.vsu_sense#branch` probe. A post-layout extracted netlist has no
* such hierarchy to tap: `klt extract` flattens the block, so
* bandgap_startup's four devices sit at the same level as everything else
* and no series ammeter can be inserted without editing the extracted
* netlist -- which would stop it being the extracted netlist.
*
* What this bench therefore measures, and does not:
*
* - startup_time_s, vref_final_v, iq_total_final_ua, det_final_v, t0_s,
*   t_settle_s -- all identical in definition to sim/startup/'s, so the
*   two records are directly comparable line for line.
* - iq_startup_branch_final_ua -- NOT measured here. The startup branch's
*   own residual supply current cannot be isolated on a flat netlist. The
*   disengagement evidence this bench does carry is `det_final_v`: the
*   detect node sitting well below nfet_03v3's Vth means MKFB/MKCASC are
*   firmly off, i.e. the branch has disengaged, which is the behavioural
*   half of DR-0001's requirement. The current half stays with the
*   schematic-level record.
*
* The DUT is whatever `tb.json`'s "dut" key (or --dut) names; the record's
* Netlist provenance field says which. The probed internal node
* `xtop.startup_det` is the same physical node sim/startup/ reaches at
* `xtop.xx3.det` -- the extracted netlist is flat, so the schematic's
* `xx3.det` appears at the top of the `bandgap_top` subcircuit under the
* name `klt lvs` paired it with. A schematic-side DUT
* (sim/dut/bandgap_top.spice) does NOT expose that node under that name,
* so this bench is meaningful only against an extracted netlist; the
* schematic-level claim stays with sim/startup/.
*
* Supply drive: a single PWL ramp from 0 V to vdd_val over {tramp}
* seconds, then held -- byte-identical in intent to sim/startup/'s, with
* the same "no .ic / .nodeset, the transient's own t=0 operating point is
* the real power-up condition" reasoning.

vsup vdd 0 pwl(0 0 {tramp} {vdd_val} 10 {vdd_val})
Xtop vdd 0 vref bandgap_top

* ---------------------------------------------------------------
* DUT netlist included by this testbench (extracted)
* source     : layout/netlist/bandgap_top_extracted.spice
* sha256     : eea17aad965755204a6ddccf1397d2fc969a2bca1cc48343a0a793bffa326356
* ---------------------------------------------------------------

* Post-layout EXTRACTED DUT netlist -- GENERATED, do not edit by hand.
*
* extract report : layout/netlist/reports/bandgap_top/20260803-054749-8d21bf1.extract.json
* extracted spice: layout/netlist/reports/bandgap_top/20260803-054749-8d21bf1.extracted.spice
* lvs report     : layout/lvs/reports/bandgap_top/20260803-054735-8d21bf1.lvs.json
* layout gds     : layout/bandgap_top/bandgap_top.gds
* extraction deck: gf180mcu  (klt extract --parasitics)
* pdk            : gf180mcuD open_pdks c6d73a35f524070e85faff4a6a9eef49553ebc2b
* devices        : 156 {'bjt': 8, 'cap_mim_2f0_m4m5_noshield': 1, 'nfet': 34, 'pfet': 47, 'ppolyf_u': 65, 'ppolyf_u_1k': 1}
*   parasitics    : 82 R / 82 C, 209221.9 ohm and 2479.2 fF total
* regenerate     : python3 layout/netlist/mk_extracted_dut.py --extract layout/netlist/reports/bandgap_top/20260803-054749-8d21bf1.extract.json --lvs layout/lvs/reports/bandgap_top/20260803-054735-8d21bf1.lvs.json -o layout/netlist/bandgap_top_extracted.spice
*
* sha256 (this file, sans this line): 5bfa4dc9d1ce78e4b2cd5a4dc5a0b00b
* Provenance class is derived from the path by sim/dut: a netlist under
* layout/ reports itself as `Netlist provenance: extracted`.
*
* ------------------------------------------------------------------
* Mechanical transforms applied to the extractor's own output
* ------------------------------------------------------------------
* T1. Net names: the extractor's anonymous `$<n>` labels are replaced by
*     the schematic-side names `klt lvs` paired them with (its
*     `net_correspondence` table), lowercased. Nets with no pairing keep a
*     mechanical `x<n>` name. This is a rename only -- no net is merged or
*     split by it.
* T2. Escaping: ngspice treats a space-delimited `$` as an end-of-line
*     comment, so KLayout's `\$<n>` node spelling would truncate device
*     cards. T1's rename removes every `$` from the deck.
* T3. MOS cards: `X<n> d g s b nfet|pfet L=..U W=..U` is rebound to the
*     gf180mcu `nfet_03v3`/`pfet_03v3` subcircuit with `nf=1 m=1` -- each
*     extracted device is one drawn finger, so the schematic's `nf`
*     multiplier is already spent as real, separately-extracted geometry.
* T4. Resistor cards: `R<n> a b w <ohms> ppolyf_u[_1k]` -- a bare, linear,
*     value-only card the extraction engine writes -- is rebound to the
*     gf180mcu `ppolyf_u`/`ppolyf_u_1k` subcircuit with the *drawn*
*     `r_length`/`r_width` the extractor measured off the marker geometry.
*     This restores the PDK model's own temperature coefficient and
*     mismatch statistics, which a bare ohms value has none of.
* T5. Bipolar cards: `Q<n> c b e bjt AE=..` is rebound to the gf180mcu
*     `pnp_<WxL>` subcircuit selected by the extractor's own measured `AE`
*     (25 um^2 -> pnp_05p00x05p00). Each drawn unit stays a separate
*     device; the schematic's 10x10 PNP is four parallel drawn 5x5 units.
* T6. MOS junction geometry: the extractor emits no `AS/AD/PS/PD` (a
*     stated scope limit of its PDK-model binding), which would leave
*     every source/drain junction capacitance at zero. They are recomputed
*     from *drawn* geometry: `generate.draw_mos` gives each finger its own
*     COMP island with two unshared 0.9 um source/drain columns, so
*     AS=AD=W*0.9u and PS=PD=2*(W+0.9u) exactly. `NRS/NRD` are left at the
*     PDK default (0): the drawn contact columns fill the whole diffusion
*     width, so sheet-resistance-to-contact is negligible.
* T7. MiM cap card: `C<n> a b <farads> cap_mim_...` is rebound to the
*     gf180mcu `cap_mim_2f0_m4m5_noshield` subcircuit with the drawn plate
*     dimensions (from the extractor's measured plate area), restoring the
*     PDK model's voltage/temperature coefficients and leakage.
* T8. Parasitics: `klt extract --parasitics`'s per-net first-order lumped
*     RC (net -> R -> internal node -> C -> substrate) is carried through
*     verbatim, with T1's names applied.
* T9. Pin list: the extracted top cell's `vdd vref vss vsubs` is emitted
*     as `bandgap_top vdd vss vref` to match `sim/dut/README.md`'s
*     three-pin convention, with `vsubs` aliased per BA1 below.
*
* ------------------------------------------------------------------
* Back-annotated nets: terminals the extraction deck cannot resolve
* ------------------------------------------------------------------
* BA1  substrate `vsubs` -> `vss`      (deck has no p-substrate tap layer)
* BA2  PMOS well net    -> `vdd`      (deck has no well-tap layer)
* BA3  8 PNP base nets  -> `vss`      (Nwell is not a connectivity metal;
*      the capacitor-plate gap klayout-tools#314 fixed, still open for
*      BipolarDevice -- filed upstream, see layout/netlist/README.md)
* (BA4, the MiM cap top plate, is gone as of gf180-bandgap#88: the redrawn
*  Via4 lands inside the recognised top plate and extracts on the real `fb`
*  net with no back-annotation -- see this file's build_back_annotations().)
*
* Applied merges (source -> target, in extractor net names):
*   BA1: vsubs -> vss
*   BA2: $33 -> vdd
*   BA3: $23 -> vss
*   BA3: $24 -> vss
*   BA3: $26 -> vss
*   BA3: $28 -> vss
*   BA3: $29 -> vss
*   BA3: $30 -> vss
*   BA3: $31 -> vss
*   BA3: $32 -> vss
*
* Everything else -- device existence, class, connectivity, drawn
* resistor L/W, drawn plate area, drawn finger and PNP-unit counts, and
* the per-net RC parasitics -- is measured, not asserted.

.subckt bandgap_top vdd vss vref

XQ82 vss vss vss pnp_05p00x05p00 m=1
XQ83 vss vss core_e3 pnp_05p00x05p00 m=1
XQ84 vss vss core_e2 pnp_05p00x05p00 m=1
XQ85 vss vss core_e2 pnp_05p00x05p00 m=1
XQ86 vss vss sns1 pnp_05p00x05p00 m=1
XQ87 vss vss core_e2 pnp_05p00x05p00 m=1
XQ88 vss vss core_e2 pnp_05p00x05p00 m=1
XQ89 vss vss vss pnp_05p00x05p00 m=1
XC90 vdd fb cap_mim_2f0_m4m5_noshield c_width=58.8u c_length=58.8u m=1
XM1 ibias ibias vss vss nfet_03v3 L=2u W=2.5u nf=1 ad=2.25p as=2.25p pd=6.8u ps=6.8u m=1
XM10 amp_nd1 amp_ncasc amp_n1 vss nfet_03v3 L=16u W=10u nf=1 ad=9p as=9p pd=21.8u ps=21.8u m=1
XM11 amp_ncasc amp_ncasc amp_nb1 vss nfet_03v3 L=4u W=1u nf=1 ad=0.9p as=0.9p pd=3.8u ps=3.8u m=1
XM12 amp_nb1 amp_nb1 vss vss nfet_03v3 L=4u W=1u nf=1 ad=0.9p as=0.9p pd=3.8u ps=3.8u m=1
XM13 fb amp_ncasc amp_n2 vss nfet_03v3 L=16u W=10u nf=1 ad=9p as=9p pd=21.8u ps=21.8u m=1
XM14 fb amp_ncasc amp_n2 vss nfet_03v3 L=16u W=10u nf=1 ad=9p as=9p pd=21.8u ps=21.8u m=1
XM15 amp_nd1 amp_ncasc amp_n1 vss nfet_03v3 L=16u W=10u nf=1 ad=9p as=9p pd=21.8u ps=21.8u m=1
XM16 vss vss vss vss nfet_03v3 L=16u W=2u nf=1 ad=1.8p as=1.8p pd=5.8u ps=5.8u m=1
XM17 vss vss vss vss nfet_03v3 L=4u W=2u nf=1 ad=1.8p as=1.8p pd=5.8u ps=5.8u m=1
XM18 amp_n1 sns2 amp_tail vss nfet_03v3 L=4u W=25u nf=1 ad=22.5p as=22.5p pd=51.8u ps=51.8u m=1
XM19 amp_n2 sns1 amp_tail vss nfet_03v3 L=4u W=25u nf=1 ad=22.5p as=22.5p pd=51.8u ps=51.8u m=1
XM2 casc ibias vss vss nfet_03v3 L=2u W=5u nf=1 ad=4.5p as=4.5p pd=11.8u ps=11.8u m=1
XM20 amp_n2 sns1 amp_tail vss nfet_03v3 L=4u W=25u nf=1 ad=22.5p as=22.5p pd=51.8u ps=51.8u m=1
XM21 amp_n1 sns2 amp_tail vss nfet_03v3 L=4u W=25u nf=1 ad=22.5p as=22.5p pd=51.8u ps=51.8u m=1
XM22 amp_n1 sns2 amp_tail vss nfet_03v3 L=4u W=25u nf=1 ad=22.5p as=22.5p pd=51.8u ps=51.8u m=1
XM23 amp_n2 sns1 amp_tail vss nfet_03v3 L=4u W=25u nf=1 ad=22.5p as=22.5p pd=51.8u ps=51.8u m=1
XM24 amp_n2 sns1 amp_tail vss nfet_03v3 L=4u W=25u nf=1 ad=22.5p as=22.5p pd=51.8u ps=51.8u m=1
XM25 amp_n1 sns2 amp_tail vss nfet_03v3 L=4u W=25u nf=1 ad=22.5p as=22.5p pd=51.8u ps=51.8u m=1
XM26 amp_n1 sns2 amp_tail vss nfet_03v3 L=4u W=25u nf=1 ad=22.5p as=22.5p pd=51.8u ps=51.8u m=1
XM27 amp_n2 sns1 amp_tail vss nfet_03v3 L=4u W=25u nf=1 ad=22.5p as=22.5p pd=51.8u ps=51.8u m=1
XM28 amp_n2 sns1 amp_tail vss nfet_03v3 L=4u W=25u nf=1 ad=22.5p as=22.5p pd=51.8u ps=51.8u m=1
XM29 amp_n1 sns2 amp_tail vss nfet_03v3 L=4u W=25u nf=1 ad=22.5p as=22.5p pd=51.8u ps=51.8u m=1
XM3 startup_det ibias vss vss nfet_03v3 L=2u W=10u nf=1 ad=9p as=9p pd=21.8u ps=21.8u m=1
XM30 amp_n1 sns2 amp_tail vss nfet_03v3 L=4u W=25u nf=1 ad=22.5p as=22.5p pd=51.8u ps=51.8u m=1
XM31 amp_n2 sns1 amp_tail vss nfet_03v3 L=4u W=25u nf=1 ad=22.5p as=22.5p pd=51.8u ps=51.8u m=1
XM32 amp_n2 sns1 amp_tail vss nfet_03v3 L=4u W=25u nf=1 ad=22.5p as=22.5p pd=51.8u ps=51.8u m=1
XM33 amp_n1 sns2 amp_tail vss nfet_03v3 L=4u W=25u nf=1 ad=22.5p as=22.5p pd=51.8u ps=51.8u m=1
XM34 vss vss vss vss nfet_03v3 L=4u W=2u nf=1 ad=1.8p as=1.8p pd=5.8u ps=5.8u m=1
XM4 startup_det ibias vss vss nfet_03v3 L=2u W=10u nf=1 ad=9p as=9p pd=21.8u ps=21.8u m=1
XM5 fb startup_det vss vss nfet_03v3 L=2u W=2u nf=1 ad=1.8p as=1.8p pd=5.8u ps=5.8u m=1
XM6 casc startup_det vss vss nfet_03v3 L=2u W=2u nf=1 ad=1.8p as=1.8p pd=5.8u ps=5.8u m=1
XM7 vss vss vss vss nfet_03v3 L=16u W=2u nf=1 ad=1.8p as=1.8p pd=5.8u ps=5.8u m=1
XM8 amp_tail ibias vss vss nfet_03v3 L=4u W=10u nf=1 ad=9p as=9p pd=21.8u ps=21.8u m=1
XM9 amp_pbias ibias vss vss nfet_03v3 L=16u W=2u nf=1 ad=1.8p as=1.8p pd=5.8u ps=5.8u m=1
XM35 vdd vdd vdd vdd pfet_03v3 L=16u W=2u nf=1 ad=1.8p as=1.8p pd=5.8u ps=5.8u m=1
XM36 amp_nd1 amp_pbias amp_a3 vdd pfet_03v3 L=16u W=20u nf=1 ad=18p as=18p pd=41.8u ps=41.8u m=1
XM37 fb amp_pbias amp_a4 vdd pfet_03v3 L=16u W=20u nf=1 ad=18p as=18p pd=41.8u ps=41.8u m=1
XM38 fb amp_pbias amp_a4 vdd pfet_03v3 L=16u W=20u nf=1 ad=18p as=18p pd=41.8u ps=41.8u m=1
XM39 amp_nd1 amp_pbias amp_a3 vdd pfet_03v3 L=16u W=20u nf=1 ad=18p as=18p pd=41.8u ps=41.8u m=1
XM40 vdd vdd vdd vdd pfet_03v3 L=16u W=2u nf=1 ad=1.8p as=1.8p pd=5.8u ps=5.8u m=1
XM41 vdd vdd vdd vdd pfet_03v3 L=16u W=2u nf=1 ad=1.8p as=1.8p pd=5.8u ps=5.8u m=1
XM42 amp_a3 amp_nd1 vdd vdd pfet_03v3 L=16u W=10u nf=1 ad=9p as=9p pd=21.8u ps=21.8u m=1
XM43 amp_a4 amp_nd1 vdd vdd pfet_03v3 L=16u W=10u nf=1 ad=9p as=9p pd=21.8u ps=21.8u m=1
XM44 amp_a4 amp_nd1 vdd vdd pfet_03v3 L=16u W=10u nf=1 ad=9p as=9p pd=21.8u ps=21.8u m=1
XM45 amp_a3 amp_nd1 vdd vdd pfet_03v3 L=16u W=10u nf=1 ad=9p as=9p pd=21.8u ps=21.8u m=1
XM46 vdd vdd vdd vdd pfet_03v3 L=16u W=2u nf=1 ad=1.8p as=1.8p pd=5.8u ps=5.8u m=1
XM47 vdd vdd vdd vdd pfet_03v3 L=6u W=2u nf=1 ad=1.8p as=1.8p pd=5.8u ps=5.8u m=1
XM48 casc casc vdd vdd pfet_03v3 L=12u W=4u nf=1 ad=3.6p as=3.6p pd=9.8u ps=9.8u m=1
XM49 core_d4 fb vdd vdd pfet_03v3 L=6u W=7.5u nf=1 ad=6.75p as=6.75p pd=16.8u ps=16.8u m=1
XM50 amp_pbias amp_pbias vdd vdd pfet_03v3 L=50u W=1u nf=1 ad=0.9p as=0.9p pd=3.8u ps=3.8u m=1
XM51 ibias casc core_d4 vdd pfet_03v3 L=6u W=7.5u nf=1 ad=6.75p as=6.75p pd=16.8u ps=16.8u m=1
XM52 vdd vdd vdd vdd pfet_03v3 L=6u W=2u nf=1 ad=1.8p as=1.8p pd=5.8u ps=5.8u m=1
XM53 amp_ncasc amp_pbias vdd vdd pfet_03v3 L=50u W=5u nf=1 ad=4.5p as=4.5p pd=11.8u ps=11.8u m=1
XM54 vdd vdd vdd vdd pfet_03v3 L=6u W=2u nf=1 ad=1.8p as=1.8p pd=5.8u ps=5.8u m=1
XM55 sns1 casc core_d1 vdd pfet_03v3 L=6u W=15u nf=1 ad=13.5p as=13.5p pd=31.8u ps=31.8u m=1
XM56 sns2 casc core_d2 vdd pfet_03v3 L=6u W=15u nf=1 ad=13.5p as=13.5p pd=31.8u ps=31.8u m=1
XM57 vref casc core_d3 vdd pfet_03v3 L=6u W=15u nf=1 ad=13.5p as=13.5p pd=31.8u ps=31.8u m=1
XM58 vref casc core_d3 vdd pfet_03v3 L=6u W=15u nf=1 ad=13.5p as=13.5p pd=31.8u ps=31.8u m=1
XM59 sns2 casc core_d2 vdd pfet_03v3 L=6u W=15u nf=1 ad=13.5p as=13.5p pd=31.8u ps=31.8u m=1
XM60 sns1 casc core_d1 vdd pfet_03v3 L=6u W=15u nf=1 ad=13.5p as=13.5p pd=31.8u ps=31.8u m=1
XM61 sns1 casc core_d1 vdd pfet_03v3 L=6u W=15u nf=1 ad=13.5p as=13.5p pd=31.8u ps=31.8u m=1
XM62 sns2 casc core_d2 vdd pfet_03v3 L=6u W=15u nf=1 ad=13.5p as=13.5p pd=31.8u ps=31.8u m=1
XM63 vref casc core_d3 vdd pfet_03v3 L=6u W=15u nf=1 ad=13.5p as=13.5p pd=31.8u ps=31.8u m=1
XM64 vref casc core_d3 vdd pfet_03v3 L=6u W=15u nf=1 ad=13.5p as=13.5p pd=31.8u ps=31.8u m=1
XM65 sns2 casc core_d2 vdd pfet_03v3 L=6u W=15u nf=1 ad=13.5p as=13.5p pd=31.8u ps=31.8u m=1
XM66 sns1 casc core_d1 vdd pfet_03v3 L=6u W=15u nf=1 ad=13.5p as=13.5p pd=31.8u ps=31.8u m=1
XM67 vdd vdd vdd vdd pfet_03v3 L=6u W=2u nf=1 ad=1.8p as=1.8p pd=5.8u ps=5.8u m=1
XM68 vdd vdd vdd vdd pfet_03v3 L=6u W=2u nf=1 ad=1.8p as=1.8p pd=5.8u ps=5.8u m=1
XM69 core_d1 fb vdd vdd pfet_03v3 L=6u W=15u nf=1 ad=13.5p as=13.5p pd=31.8u ps=31.8u m=1
XM70 core_d2 fb vdd vdd pfet_03v3 L=6u W=15u nf=1 ad=13.5p as=13.5p pd=31.8u ps=31.8u m=1
XM71 core_d3 fb vdd vdd pfet_03v3 L=6u W=15u nf=1 ad=13.5p as=13.5p pd=31.8u ps=31.8u m=1
XM72 core_d3 fb vdd vdd pfet_03v3 L=6u W=15u nf=1 ad=13.5p as=13.5p pd=31.8u ps=31.8u m=1
XM73 core_d2 fb vdd vdd pfet_03v3 L=6u W=15u nf=1 ad=13.5p as=13.5p pd=31.8u ps=31.8u m=1
XM74 core_d1 fb vdd vdd pfet_03v3 L=6u W=15u nf=1 ad=13.5p as=13.5p pd=31.8u ps=31.8u m=1
XM75 core_d1 fb vdd vdd pfet_03v3 L=6u W=15u nf=1 ad=13.5p as=13.5p pd=31.8u ps=31.8u m=1
XM76 core_d2 fb vdd vdd pfet_03v3 L=6u W=15u nf=1 ad=13.5p as=13.5p pd=31.8u ps=31.8u m=1
XM77 core_d3 fb vdd vdd pfet_03v3 L=6u W=15u nf=1 ad=13.5p as=13.5p pd=31.8u ps=31.8u m=1
XM78 core_d3 fb vdd vdd pfet_03v3 L=6u W=15u nf=1 ad=13.5p as=13.5p pd=31.8u ps=31.8u m=1
XM79 core_d2 fb vdd vdd pfet_03v3 L=6u W=15u nf=1 ad=13.5p as=13.5p pd=31.8u ps=31.8u m=1
XM80 core_d1 fb vdd vdd pfet_03v3 L=6u W=15u nf=1 ad=13.5p as=13.5p pd=31.8u ps=31.8u m=1
XM81 vdd vdd vdd vdd pfet_03v3 L=6u W=2u nf=1 ad=1.8p as=1.8p pd=5.8u ps=5.8u m=1
XR100 core_tn0 core_trim_u3_0 vss ppolyf_u r_width=2u r_length=2.772u m=1
XR101 core_trim_u3_0 core_trim_u3_1 vss ppolyf_u r_width=2u r_length=2.772u m=1
XR102 core_trim_u3_1 core_trim_u3_2 vss ppolyf_u r_width=2u r_length=2.772u m=1
XR103 core_trim_u3_2 core_trim_u3_3 vss ppolyf_u r_width=2u r_length=2.772u m=1
XR104 core_trim_u3_3 core_trim_u3_4 vss ppolyf_u r_width=2u r_length=2.772u m=1
XR105 core_trim_u3_4 core_trim_u3_5 vss ppolyf_u r_width=2u r_length=2.772u m=1
XR106 core_trim_u3_5 core_trim_u3_6 vss ppolyf_u r_width=2u r_length=2.772u m=1
XR107 core_trim_u3_6 core_tn0 vss ppolyf_u r_width=2u r_length=2.772u m=1
XR108 core_tn0 core_trim_u4_0 vss ppolyf_u r_width=2u r_length=2.772u m=1
XR109 core_trim_u4_0 core_trim_u4_1 vss ppolyf_u r_width=2u r_length=2.772u m=1
XR110 core_trim_u4_1 core_trim_u4_2 vss ppolyf_u r_width=2u r_length=2.772u m=1
XR111 core_trim_u4_2 core_trim_u4_3 vss ppolyf_u r_width=2u r_length=2.772u m=1
XR112 core_trim_u4_3 core_trim_u4_4 vss ppolyf_u r_width=2u r_length=2.772u m=1
XR113 core_trim_u4_4 core_trim_u4_5 vss ppolyf_u r_width=2u r_length=2.772u m=1
XR114 core_trim_u4_5 core_trim_u4_6 vss ppolyf_u r_width=2u r_length=2.772u m=1
XR115 core_trim_u4_6 core_trim_u4_7 vss ppolyf_u r_width=2u r_length=2.772u m=1
XR116 core_trim_u4_7 core_trim_u4_8 vss ppolyf_u r_width=2u r_length=2.772u m=1
XR117 core_trim_u4_8 core_trim_u4_9 vss ppolyf_u r_width=2u r_length=2.772u m=1
XR118 core_trim_u4_9 core_trim_u4_10 vss ppolyf_u r_width=2u r_length=2.772u m=1
XR119 core_trim_u4_10 core_trim_u4_11 vss ppolyf_u r_width=2u r_length=2.772u m=1
XR120 core_trim_u4_11 core_trim_u4_12 vss ppolyf_u r_width=2u r_length=2.772u m=1
XR121 core_trim_u4_12 core_trim_u4_13 vss ppolyf_u r_width=2u r_length=2.772u m=1
XR122 core_trim_u4_13 core_trim_u4_14 vss ppolyf_u r_width=2u r_length=2.772u m=1
XR123 core_trim_u4_14 core_tn0 vss ppolyf_u r_width=2u r_length=2.772u m=1
XR124 vref core_trim_u5_30 vss ppolyf_u r_width=2u r_length=2.772u m=1
XR125 core_trim_u5_30 core_trim_u5_29 vss ppolyf_u r_width=2u r_length=2.772u m=1
XR126 core_trim_u5_29 core_trim_u5_28 vss ppolyf_u r_width=2u r_length=2.772u m=1
XR127 core_trim_u5_28 core_trim_u5_27 vss ppolyf_u r_width=2u r_length=2.772u m=1
XR128 core_trim_u5_27 core_trim_u5_26 vss ppolyf_u r_width=2u r_length=2.772u m=1
XR129 core_trim_u5_26 core_trim_u5_25 vss ppolyf_u r_width=2u r_length=2.772u m=1
XR130 core_trim_u5_25 core_trim_u5_24 vss ppolyf_u r_width=2u r_length=2.772u m=1
XR131 core_trim_u5_24 core_trim_u5_23 vss ppolyf_u r_width=2u r_length=2.772u m=1
XR132 core_trim_u5_23 core_trim_u5_22 vss ppolyf_u r_width=2u r_length=2.772u m=1
XR133 core_trim_u5_22 core_trim_u5_21 vss ppolyf_u r_width=2u r_length=2.772u m=1
XR134 core_trim_u5_21 core_trim_u5_20 vss ppolyf_u r_width=2u r_length=2.772u m=1
XR135 core_trim_u5_20 core_trim_u5_19 vss ppolyf_u r_width=2u r_length=2.772u m=1
XR136 core_trim_u5_19 core_trim_u5_18 vss ppolyf_u r_width=2u r_length=2.772u m=1
XR137 core_trim_u5_18 core_trim_u5_17 vss ppolyf_u r_width=2u r_length=2.772u m=1
XR138 core_trim_u5_17 core_trim_u5_16 vss ppolyf_u r_width=2u r_length=2.772u m=1
XR139 core_trim_u5_16 core_trim_u5_15 vss ppolyf_u r_width=2u r_length=2.772u m=1
XR140 core_trim_u5_15 core_trim_u5_14 vss ppolyf_u r_width=2u r_length=2.772u m=1
XR141 core_trim_u5_14 core_trim_u5_13 vss ppolyf_u r_width=2u r_length=2.772u m=1
XR142 core_trim_u5_13 core_trim_u5_12 vss ppolyf_u r_width=2u r_length=2.772u m=1
XR143 core_trim_u5_12 core_trim_u5_11 vss ppolyf_u r_width=2u r_length=2.772u m=1
XR144 core_trim_u5_11 core_trim_u5_10 vss ppolyf_u r_width=2u r_length=2.772u m=1
XR145 core_trim_u5_10 core_trim_u5_9 vss ppolyf_u r_width=2u r_length=2.772u m=1
XR146 core_trim_u5_9 core_trim_u5_8 vss ppolyf_u r_width=2u r_length=2.772u m=1
XR147 core_trim_u5_8 core_trim_u5_7 vss ppolyf_u r_width=2u r_length=2.772u m=1
XR148 core_trim_u5_7 core_trim_u5_6 vss ppolyf_u r_width=2u r_length=2.772u m=1
XR149 core_trim_u5_6 core_trim_u5_5 vss ppolyf_u r_width=2u r_length=2.772u m=1
XR150 core_trim_u5_5 core_trim_u5_4 vss ppolyf_u r_width=2u r_length=2.772u m=1
XR151 core_trim_u5_4 core_trim_u5_3 vss ppolyf_u r_width=2u r_length=2.772u m=1
XR152 core_trim_u5_3 core_trim_u5_2 vss ppolyf_u r_width=2u r_length=2.772u m=1
XR153 core_trim_u5_2 core_trim_u5_1 vss ppolyf_u r_width=2u r_length=2.772u m=1
XR154 core_trim_u5_1 core_trim_u5_0 vss ppolyf_u r_width=2u r_length=2.772u m=1
XR155 core_trim_u5_0 core_tn0 vss ppolyf_u r_width=2u r_length=2.772u m=1
XR91 core_e2 sns2 vss ppolyf_u r_width=2u r_length=36.34u m=1
XR92 core_tn0 core_tn0 vss ppolyf_u r_width=2u r_length=2.772u m=1
XR93 core_tn0 core_trim_u1_0 vss ppolyf_u r_width=2u r_length=2.772u m=1
XR94 core_trim_u1_0 core_tn0 vss ppolyf_u r_width=2u r_length=2.772u m=1
XR95 core_e3 core_tn0 vss ppolyf_u r_width=2u r_length=436.704u m=1
XR96 core_tn0 core_trim_u2_0 vss ppolyf_u r_width=2u r_length=2.772u m=1
XR97 core_trim_u2_0 core_trim_u2_1 vss ppolyf_u r_width=2u r_length=2.772u m=1
XR98 core_trim_u2_1 core_trim_u2_2 vss ppolyf_u r_width=2u r_length=2.772u m=1
XR99 core_trim_u2_2 core_tn0 vss ppolyf_u r_width=2u r_length=2.772u m=1
XR156 startup_det vdd vss ppolyf_u_1k r_width=2u r_length=3999.96u m=1

* T8: per-net first-order lumped RC parasitics (klt extract --parasitics)
R10_par amp_nd1 amp_nd1__par 8667.42
C10_par amp_nd1__par vss 9.92968e-14
R11_par amp_n2 amp_n2__par 6221.94
C11_par amp_n2__par vss 8.44109e-14
R12_par fb fb__par 9956.6
C12_par fb__par vss 1.13096e-13
R13_par amp_tail amp_tail__par 6822.51
C13_par amp_tail__par vss 1.02384e-13
R14_par amp_a3 amp_a3__par 5954.61
C14_par amp_a3__par vss 6.84169e-14
R15_par amp_a4 amp_a4__par 5847.92
C15_par amp_a4__par vss 6.42477e-14
R16_par core_d4 core_d4__par 5758.39
C16_par core_d4__par vss 4.89813e-14
R17_par core_d1 core_d1__par 6377.35
C17_par core_d1__par vss 8.05102e-14
R18_par sns1 sns1__par 7808.05
C18_par sns1__par vss 9.29593e-14
R19_par core_d2 core_d2__par 6176.88
C19_par core_d2__par vss 7.74309e-14
R20_par sns2 sns2__par 8128.19
C20_par sns2__par vss 8.97583e-14
R21_par core_d3 core_d3__par 6025.53
C21_par core_d3__par vss 7.47153e-14
R25_par core_e3 core_e3__par 5824.68
C25_par core_e3__par vss 5.17217e-14
R27_par core_e2 core_e2__par 6159.48
C27_par core_e2__par vss 6.21033e-14
R3_par ibias ibias__par 7676.66
C3_par ibias__par vss 6.91995e-14
R34_par core_trim_u1_0 core_trim_u1_0__par 83.7942
C34_par core_trim_u1_0__par vss 8.17907e-16
R35_par core_trim_u2_0 core_trim_u2_0__par 83.7942
C35_par core_trim_u2_0__par vss 8.17907e-16
R36_par core_trim_u2_1 core_trim_u2_1__par 83.7942
C36_par core_trim_u2_1__par vss 8.17907e-16
R37_par core_trim_u2_2 core_trim_u2_2__par 83.7942
C37_par core_trim_u2_2__par vss 8.17907e-16
R38_par core_trim_u3_0 core_trim_u3_0__par 83.7942
C38_par core_trim_u3_0__par vss 8.17907e-16
R39_par core_trim_u3_1 core_trim_u3_1__par 83.7942
C39_par core_trim_u3_1__par vss 8.17907e-16
R4_par casc casc__par 10940.6
C4_par casc__par vss 1.04268e-13
R40_par core_trim_u3_2 core_trim_u3_2__par 83.7942
C40_par core_trim_u3_2__par vss 8.17907e-16
R41_par core_trim_u3_3 core_trim_u3_3__par 83.7942
C41_par core_trim_u3_3__par vss 8.17907e-16
R42_par core_trim_u3_4 core_trim_u3_4__par 83.7942
C42_par core_trim_u3_4__par vss 8.17907e-16
R43_par core_trim_u3_5 core_trim_u3_5__par 83.7942
C43_par core_trim_u3_5__par vss 8.17907e-16
R44_par core_trim_u3_6 core_trim_u3_6__par 83.7942
C44_par core_trim_u3_6__par vss 8.17907e-16
R45_par core_trim_u4_0 core_trim_u4_0__par 83.7942
C45_par core_trim_u4_0__par vss 8.17907e-16
R46_par core_trim_u4_1 core_trim_u4_1__par 83.7942
C46_par core_trim_u4_1__par vss 8.17907e-16
R47_par core_trim_u4_2 core_trim_u4_2__par 83.7942
C47_par core_trim_u4_2__par vss 8.17907e-16
R48_par core_trim_u4_3 core_trim_u4_3__par 83.7942
C48_par core_trim_u4_3__par vss 8.17907e-16
R49_par core_trim_u4_4 core_trim_u4_4__par 83.7942
C49_par core_trim_u4_4__par vss 8.17907e-16
R5_par startup_det startup_det__par 6510.21
C5_par startup_det__par vss 6.3833e-14
R50_par core_trim_u4_5 core_trim_u4_5__par 83.7942
C50_par core_trim_u4_5__par vss 8.17907e-16
R51_par core_trim_u4_6 core_trim_u4_6__par 83.7942
C51_par core_trim_u4_6__par vss 8.17907e-16
R52_par core_trim_u4_7 core_trim_u4_7__par 83.7942
C52_par core_trim_u4_7__par vss 8.17907e-16
R53_par core_trim_u4_8 core_trim_u4_8__par 83.7942
C53_par core_trim_u4_8__par vss 8.17907e-16
R54_par core_trim_u4_9 core_trim_u4_9__par 83.7942
C54_par core_trim_u4_9__par vss 8.17907e-16
R55_par core_trim_u4_10 core_trim_u4_10__par 83.7942
C55_par core_trim_u4_10__par vss 8.17907e-16
R56_par core_trim_u4_11 core_trim_u4_11__par 83.7942
C56_par core_trim_u4_11__par vss 8.17907e-16
R57_par core_trim_u4_12 core_trim_u4_12__par 83.7942
C57_par core_trim_u4_12__par vss 8.17907e-16
R58_par core_trim_u4_13 core_trim_u4_13__par 83.7942
C58_par core_trim_u4_13__par vss 8.17907e-16
R59_par core_trim_u4_14 core_trim_u4_14__par 83.7942
C59_par core_trim_u4_14__par vss 8.17907e-16
R6_par amp_pbias amp_pbias__par 12585.8
C6_par amp_pbias__par vss 1.19604e-13
R60_par core_tn0 core_tn0__par 6418.2
C60_par core_tn0__par vss 7.26132e-14
R61_par core_trim_u5_30 core_trim_u5_30__par 83.7942
C61_par core_trim_u5_30__par vss 8.17907e-16
R62_par core_trim_u5_29 core_trim_u5_29__par 83.7942
C62_par core_trim_u5_29__par vss 8.17907e-16
R63_par core_trim_u5_28 core_trim_u5_28__par 83.7942
C63_par core_trim_u5_28__par vss 8.17907e-16
R64_par core_trim_u5_27 core_trim_u5_27__par 83.7942
C64_par core_trim_u5_27__par vss 8.17907e-16
R65_par core_trim_u5_26 core_trim_u5_26__par 83.7942
C65_par core_trim_u5_26__par vss 8.17907e-16
R66_par core_trim_u5_25 core_trim_u5_25__par 83.7942
C66_par core_trim_u5_25__par vss 8.17907e-16
R67_par core_trim_u5_24 core_trim_u5_24__par 83.7942
C67_par core_trim_u5_24__par vss 8.17907e-16
R68_par core_trim_u5_23 core_trim_u5_23__par 83.7942
C68_par core_trim_u5_23__par vss 8.17907e-16
R69_par core_trim_u5_22 core_trim_u5_22__par 83.7942
C69_par core_trim_u5_22__par vss 8.17907e-16
R7_par amp_nb1 amp_nb1__par 6598.44
C7_par amp_nb1__par vss 5.62058e-14
R70_par core_trim_u5_21 core_trim_u5_21__par 83.7942
C70_par core_trim_u5_21__par vss 8.17907e-16
R71_par core_trim_u5_20 core_trim_u5_20__par 83.7942
C71_par core_trim_u5_20__par vss 8.17907e-16
R72_par core_trim_u5_19 core_trim_u5_19__par 83.7942
C72_par core_trim_u5_19__par vss 8.17907e-16
R73_par core_trim_u5_18 core_trim_u5_18__par 83.7942
C73_par core_trim_u5_18__par vss 8.17907e-16
R74_par core_trim_u5_17 core_trim_u5_17__par 83.7942
C74_par core_trim_u5_17__par vss 8.17907e-16
R75_par core_trim_u5_16 core_trim_u5_16__par 83.7942
C75_par core_trim_u5_16__par vss 8.17907e-16
R76_par core_trim_u5_15 core_trim_u5_15__par 83.7942
C76_par core_trim_u5_15__par vss 8.17907e-16
R77_par core_trim_u5_14 core_trim_u5_14__par 83.7942
C77_par core_trim_u5_14__par vss 8.17907e-16
R78_par core_trim_u5_13 core_trim_u5_13__par 83.7942
C78_par core_trim_u5_13__par vss 8.17907e-16
R79_par core_trim_u5_12 core_trim_u5_12__par 83.7942
C79_par core_trim_u5_12__par vss 8.17907e-16
R8_par amp_ncasc amp_ncasc__par 9113.48
C8_par amp_ncasc__par vss 9.50311e-14
R80_par core_trim_u5_11 core_trim_u5_11__par 83.7942
C80_par core_trim_u5_11__par vss 8.17907e-16
R81_par core_trim_u5_10 core_trim_u5_10__par 83.7942
C81_par core_trim_u5_10__par vss 8.17907e-16
R82_par core_trim_u5_9 core_trim_u5_9__par 83.7942
C82_par core_trim_u5_9__par vss 8.17907e-16
R83_par core_trim_u5_8 core_trim_u5_8__par 83.7942
C83_par core_trim_u5_8__par vss 8.17907e-16
R84_par core_trim_u5_7 core_trim_u5_7__par 83.7942
C84_par core_trim_u5_7__par vss 8.17907e-16
R85_par core_trim_u5_6 core_trim_u5_6__par 83.7942
C85_par core_trim_u5_6__par vss 8.17907e-16
R86_par core_trim_u5_5 core_trim_u5_5__par 83.7942
C86_par core_trim_u5_5__par vss 8.17907e-16
R87_par core_trim_u5_4 core_trim_u5_4__par 83.7942
C87_par core_trim_u5_4__par vss 8.17907e-16
R88_par core_trim_u5_3 core_trim_u5_3__par 83.7942
C88_par core_trim_u5_3__par vss 8.17907e-16
R89_par core_trim_u5_2 core_trim_u5_2__par 83.7942
C89_par core_trim_u5_2__par vss 8.17907e-16
R9_par amp_n1 amp_n1__par 6571.9
C9_par amp_n1__par vss 8.94243e-14
R90_par core_trim_u5_1 core_trim_u5_1__par 83.7942
C90_par core_trim_u5_1__par vss 8.17907e-16
R91_par core_trim_u5_0 core_trim_u5_0__par 83.7942
C91_par core_trim_u5_0__par vss 8.17907e-16
Rvdd_par vdd vdd__par 21232.3
Cvdd_par vdd__par vss 2.67856e-13
Rvref_par vref vref__par 5993.6
Cvref_par vref__par vss 6.40097e-14
Rvss_par vss vss__par 15074.8
Cvss_par vss__par vss 3.20512e-13

.ends bandgap_top
