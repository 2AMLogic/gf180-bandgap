* klt sim -- generated corner deck, do not edit
.lib /opt/pdk/gf180mcuD/libs.tech/ngspice/sm141064.ngspice typical
.lib /opt/pdk/gf180mcuD/libs.tech/ngspice/sm141064.ngspice res_typical
.lib /opt/pdk/gf180mcuD/libs.tech/ngspice/sm141064.ngspice bjt_typical
.lib /opt/pdk/gf180mcuD/libs.tech/ngspice/sm141064.ngspice diode_typical
.lib /opt/pdk/gf180mcuD/libs.tech/ngspice/sm141064.ngspice moscap_typical
.lib /opt/pdk/gf180mcuD/libs.tech/ngspice/sm141064.ngspice mimcap_typical
.include /var/tmp/eda-job-klt-sim-ec2e1a1364c1/inputs/netlist.cir
.temp 27
.meas dc isup_m40 FIND i(vsup) AT=-40
.meas dc isup_27 FIND i(vsup) AT=27
.meas dc isup_125 FIND i(vsup) AT=125
.meas dc vref_m40 FIND v(vref) AT=-40
.meas dc vref_27 FIND v(vref) AT=27
.meas dc vref_125 FIND v(vref) AT=125
.control
save all
alter vsup=3.63
dc temp -40 125 1
quit
.endc
.end
