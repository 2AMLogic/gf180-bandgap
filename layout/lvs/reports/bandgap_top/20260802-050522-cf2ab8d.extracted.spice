* extracted by klt extract --deck gf180mcu

* cell bandgap_top
* pin vdd
* pin vref
* pin vss
* pin vsubs
.SUBCKT bandgap_top vdd vref vss vsubs
* device instance $1 r0 *1 18.8,72.405 nfet
M$1 \$3 \$3 vss vsubs nfet L=2U W=2.5U AS=2.25P AD=2.25P PS=6.8U PD=6.8U
* device instance $2 r0 *1 23.1,73.655 nfet
M$2 \$4 \$3 vss vsubs nfet L=2U W=5U AS=4.5P AD=4.5P PS=11.8U PD=11.8U
* device instance $3 r0 *1 27.4,76.155 nfet
M$3 vdd \$3 vss vsubs nfet L=2U W=10U AS=9P AD=9P PS=21.8U PD=21.8U
* device instance $4 r0 *1 31.7,76.155 nfet
M$4 vdd \$3 vss vsubs nfet L=2U W=10U AS=9P AD=9P PS=21.8U PD=21.8U
* device instance $5 r0 *1 36,72.155 nfet
M$5 \$11 vdd vss vsubs nfet L=2U W=2U AS=1.8P AD=1.8P PS=5.8U PD=5.8U
* device instance $6 r0 *1 40.3,72.155 nfet
M$6 \$4 vdd vss vsubs nfet L=2U W=2U AS=1.8P AD=1.8P PS=5.8U PD=5.8U
* device instance $7 r0 *1 25.8,103.115 nfet
M$7 vss vss vss vsubs nfet L=16U W=2U AS=1.8P AD=1.8P PS=5.8U PD=5.8U
* device instance $8 r0 *1 19.8,91.315 nfet
M$8 \$12 \$3 vss vsubs nfet L=4U W=10U AS=9P AD=9P PS=21.8U PD=21.8U
* device instance $9 r0 *1 32.1,87.315 nfet
M$9 \$5 \$3 vss vsubs nfet L=16U W=2U AS=1.8P AD=1.8P PS=5.8U PD=5.8U
* device instance $10 r0 *1 44.1,107.115 nfet
M$10 \$9 \$7 \$8 vsubs nfet L=16U W=10U AS=9P AD=9P PS=21.8U PD=21.8U
* device instance $11 r0 *1 44.4,86.815 nfet
M$11 \$7 \$7 \$6 vsubs nfet L=4U W=1U AS=0.9P AD=0.9P PS=3.8U PD=3.8U
* device instance $12 r0 *1 50.7,86.815 nfet
M$12 \$6 \$6 vss vsubs nfet L=4U W=1U AS=0.9P AD=0.9P PS=3.8U PD=3.8U
* device instance $13 r0 *1 62.4,107.115 nfet
M$13 \$11 \$7 \$10 vsubs nfet L=16U W=10U AS=9P AD=9P PS=21.8U PD=21.8U
* device instance $14 r0 *1 80.7,107.115 nfet
M$14 \$11 \$7 \$10 vsubs nfet L=16U W=10U AS=9P AD=9P PS=21.8U PD=21.8U
* device instance $15 r0 *1 99,107.115 nfet
M$15 \$9 \$7 \$8 vsubs nfet L=16U W=10U AS=9P AD=9P PS=21.8U PD=21.8U
* device instance $16 r0 *1 117.3,103.115 nfet
M$16 vss vss vss vsubs nfet L=16U W=2U AS=1.8P AD=1.8P PS=5.8U PD=5.8U
* device instance $17 r0 *1 19.8,118.915 nfet
M$17 vss vss vss vsubs nfet L=4U W=2U AS=1.8P AD=1.8P PS=5.8U PD=5.8U
* device instance $18 r0 *1 26.1,130.415 nfet
M$18 \$8 \$13 \$12 vsubs nfet L=4U W=25U AS=22.5P AD=22.5P PS=51.8U PD=51.8U
* device instance $19 r0 *1 32.4,130.415 nfet
M$19 \$10 \$14 \$12 vsubs nfet L=4U W=25U AS=22.5P AD=22.5P PS=51.8U PD=51.8U
* device instance $20 r0 *1 38.7,130.415 nfet
M$20 \$10 \$14 \$12 vsubs nfet L=4U W=25U AS=22.5P AD=22.5P PS=51.8U PD=51.8U
* device instance $21 r0 *1 45,130.415 nfet
M$21 \$8 \$13 \$12 vsubs nfet L=4U W=25U AS=22.5P AD=22.5P PS=51.8U PD=51.8U
* device instance $22 r0 *1 51.3,130.415 nfet
M$22 \$8 \$13 \$12 vsubs nfet L=4U W=25U AS=22.5P AD=22.5P PS=51.8U PD=51.8U
* device instance $23 r0 *1 57.6,130.415 nfet
M$23 \$10 \$14 \$12 vsubs nfet L=4U W=25U AS=22.5P AD=22.5P PS=51.8U PD=51.8U
* device instance $24 r0 *1 63.9,130.415 nfet
M$24 \$10 \$14 \$12 vsubs nfet L=4U W=25U AS=22.5P AD=22.5P PS=51.8U PD=51.8U
* device instance $25 r0 *1 70.2,130.415 nfet
M$25 \$8 \$13 \$12 vsubs nfet L=4U W=25U AS=22.5P AD=22.5P PS=51.8U PD=51.8U
* device instance $26 r0 *1 76.5,130.415 nfet
M$26 \$8 \$13 \$12 vsubs nfet L=4U W=25U AS=22.5P AD=22.5P PS=51.8U PD=51.8U
* device instance $27 r0 *1 82.8,130.415 nfet
M$27 \$10 \$14 \$12 vsubs nfet L=4U W=25U AS=22.5P AD=22.5P PS=51.8U PD=51.8U
* device instance $28 r0 *1 89.1,130.415 nfet
M$28 \$10 \$14 \$12 vsubs nfet L=4U W=25U AS=22.5P AD=22.5P PS=51.8U PD=51.8U
* device instance $29 r0 *1 95.4,130.415 nfet
M$29 \$8 \$13 \$12 vsubs nfet L=4U W=25U AS=22.5P AD=22.5P PS=51.8U PD=51.8U
* device instance $30 r0 *1 101.7,130.415 nfet
M$30 \$8 \$13 \$12 vsubs nfet L=4U W=25U AS=22.5P AD=22.5P PS=51.8U PD=51.8U
* device instance $31 r0 *1 108,130.415 nfet
M$31 \$10 \$14 \$12 vsubs nfet L=4U W=25U AS=22.5P AD=22.5P PS=51.8U PD=51.8U
* device instance $32 r0 *1 114.3,130.415 nfet
M$32 \$10 \$14 \$12 vsubs nfet L=4U W=25U AS=22.5P AD=22.5P PS=51.8U PD=51.8U
* device instance $33 r0 *1 120.6,130.415 nfet
M$33 \$8 \$13 \$12 vsubs nfet L=4U W=25U AS=22.5P AD=22.5P PS=51.8U PD=51.8U
* device instance $34 r0 *1 126.9,118.915 nfet
M$34 vss vss vss vsubs nfet L=4U W=2U AS=1.8P AD=1.8P PS=5.8U PD=5.8U
* device instance $35 r0 *1 25.8,149.715 pfet
M$35 vdd vdd vdd \$21 pfet L=16U W=2U AS=1.8P AD=1.8P PS=5.8U PD=5.8U
* device instance $36 r0 *1 44.1,158.715 pfet
M$36 \$9 \$5 \$15 \$21 pfet L=16U W=20U AS=18P AD=18P PS=41.8U PD=41.8U
* device instance $37 r0 *1 62.4,158.715 pfet
M$37 \$11 \$5 \$16 \$21 pfet L=16U W=20U AS=18P AD=18P PS=41.8U PD=41.8U
* device instance $38 r0 *1 80.7,158.715 pfet
M$38 \$11 \$5 \$16 \$21 pfet L=16U W=20U AS=18P AD=18P PS=41.8U PD=41.8U
* device instance $39 r0 *1 99,158.715 pfet
M$39 \$9 \$5 \$15 \$21 pfet L=16U W=20U AS=18P AD=18P PS=41.8U PD=41.8U
* device instance $40 r0 *1 117.3,149.715 pfet
M$40 vdd vdd vdd \$21 pfet L=16U W=2U AS=1.8P AD=1.8P PS=5.8U PD=5.8U
* device instance $41 r0 *1 25.8,175.515 pfet
M$41 vdd vdd vdd \$21 pfet L=16U W=2U AS=1.8P AD=1.8P PS=5.8U PD=5.8U
* device instance $42 r0 *1 44.1,179.515 pfet
M$42 \$15 \$9 vdd \$21 pfet L=16U W=10U AS=9P AD=9P PS=21.8U PD=21.8U
* device instance $43 r0 *1 62.4,179.515 pfet
M$43 \$16 \$9 vdd \$21 pfet L=16U W=10U AS=9P AD=9P PS=21.8U PD=21.8U
* device instance $44 r0 *1 80.7,179.515 pfet
M$44 \$16 \$9 vdd \$21 pfet L=16U W=10U AS=9P AD=9P PS=21.8U PD=21.8U
* device instance $45 r0 *1 99,179.515 pfet
M$45 \$15 \$9 vdd \$21 pfet L=16U W=10U AS=9P AD=9P PS=21.8U PD=21.8U
* device instance $46 r0 *1 117.3,175.515 pfet
M$46 vdd vdd vdd \$21 pfet L=16U W=2U AS=1.8P AD=1.8P PS=5.8U PD=5.8U
* device instance $47 r0 *1 20.8,199.555 pfet
M$47 vdd vdd vdd \$21 pfet L=6U W=2U AS=1.8P AD=1.8P PS=5.8U PD=5.8U
* device instance $48 r0 *1 23.8,191.035 pfet
M$48 \$4 \$4 vdd \$21 pfet L=12U W=4U AS=3.6P AD=3.6P PS=9.8U PD=9.8U
* device instance $49 r0 *1 29.1,202.305 pfet
M$49 \$17 \$11 vdd \$21 pfet L=6U W=7.5U AS=6.75P AD=6.75P PS=16.8U PD=16.8U
* device instance $50 r0 *1 57.1,189.535 pfet
M$50 \$5 \$5 vdd \$21 pfet L=50U W=1U AS=0.9P AD=0.9P PS=3.8U PD=3.8U
* device instance $51 r0 *1 37.4,202.305 pfet
M$51 \$3 \$4 \$17 \$21 pfet L=6U W=7.5U AS=6.75P AD=6.75P PS=16.8U PD=16.8U
* device instance $52 r0 *1 45.7,199.555 pfet
M$52 vdd vdd vdd \$21 pfet L=6U W=2U AS=1.8P AD=1.8P PS=5.8U PD=5.8U
* device instance $53 r0 *1 109.4,191.535 pfet
M$53 \$7 \$5 vdd \$21 pfet L=50U W=5U AS=4.5P AD=4.5P PS=11.8U PD=11.8U
* device instance $54 r0 *1 20.8,212.215 pfet
M$54 vdd vdd vdd \$21 pfet L=6U W=2U AS=1.8P AD=1.8P PS=5.8U PD=5.8U
* device instance $55 r0 *1 29.1,218.715 pfet
M$55 \$14 \$4 \$18 \$21 pfet L=6U W=15U AS=13.5P AD=13.5P PS=31.8U PD=31.8U
* device instance $56 r0 *1 37.4,218.715 pfet
M$56 \$13 \$4 \$19 \$21 pfet L=6U W=15U AS=13.5P AD=13.5P PS=31.8U PD=31.8U
* device instance $57 r0 *1 45.7,218.715 pfet
M$57 vref \$4 \$20 \$21 pfet L=6U W=15U AS=13.5P AD=13.5P PS=31.8U PD=31.8U
* device instance $58 r0 *1 54,218.715 pfet
M$58 vref \$4 \$20 \$21 pfet L=6U W=15U AS=13.5P AD=13.5P PS=31.8U PD=31.8U
* device instance $59 r0 *1 62.3,218.715 pfet
M$59 \$13 \$4 \$19 \$21 pfet L=6U W=15U AS=13.5P AD=13.5P PS=31.8U PD=31.8U
* device instance $60 r0 *1 70.6,218.715 pfet
M$60 \$14 \$4 \$18 \$21 pfet L=6U W=15U AS=13.5P AD=13.5P PS=31.8U PD=31.8U
* device instance $61 r0 *1 78.9,218.715 pfet
M$61 \$14 \$4 \$18 \$21 pfet L=6U W=15U AS=13.5P AD=13.5P PS=31.8U PD=31.8U
* device instance $62 r0 *1 87.2,218.715 pfet
M$62 \$13 \$4 \$19 \$21 pfet L=6U W=15U AS=13.5P AD=13.5P PS=31.8U PD=31.8U
* device instance $63 r0 *1 95.5,218.715 pfet
M$63 vref \$4 \$20 \$21 pfet L=6U W=15U AS=13.5P AD=13.5P PS=31.8U PD=31.8U
* device instance $64 r0 *1 103.8,218.715 pfet
M$64 vref \$4 \$20 \$21 pfet L=6U W=15U AS=13.5P AD=13.5P PS=31.8U PD=31.8U
* device instance $65 r0 *1 112.1,218.715 pfet
M$65 \$13 \$4 \$19 \$21 pfet L=6U W=15U AS=13.5P AD=13.5P PS=31.8U PD=31.8U
* device instance $66 r0 *1 120.4,218.715 pfet
M$66 \$14 \$4 \$18 \$21 pfet L=6U W=15U AS=13.5P AD=13.5P PS=31.8U PD=31.8U
* device instance $67 r0 *1 128.7,212.215 pfet
M$67 vdd vdd vdd \$21 pfet L=6U W=2U AS=1.8P AD=1.8P PS=5.8U PD=5.8U
* device instance $68 r0 *1 20.8,234.295 pfet
M$68 vdd vdd vdd \$21 pfet L=6U W=2U AS=1.8P AD=1.8P PS=5.8U PD=5.8U
* device instance $69 r0 *1 29.1,240.795 pfet
M$69 \$18 \$11 vdd \$21 pfet L=6U W=15U AS=13.5P AD=13.5P PS=31.8U PD=31.8U
* device instance $70 r0 *1 37.4,240.795 pfet
M$70 \$19 \$11 vdd \$21 pfet L=6U W=15U AS=13.5P AD=13.5P PS=31.8U PD=31.8U
* device instance $71 r0 *1 45.7,240.795 pfet
M$71 \$20 \$11 vdd \$21 pfet L=6U W=15U AS=13.5P AD=13.5P PS=31.8U PD=31.8U
* device instance $72 r0 *1 54,240.795 pfet
M$72 \$20 \$11 vdd \$21 pfet L=6U W=15U AS=13.5P AD=13.5P PS=31.8U PD=31.8U
* device instance $73 r0 *1 62.3,240.795 pfet
M$73 \$19 \$11 vdd \$21 pfet L=6U W=15U AS=13.5P AD=13.5P PS=31.8U PD=31.8U
* device instance $74 r0 *1 70.6,240.795 pfet
M$74 \$18 \$11 vdd \$21 pfet L=6U W=15U AS=13.5P AD=13.5P PS=31.8U PD=31.8U
* device instance $75 r0 *1 78.9,240.795 pfet
M$75 \$18 \$11 vdd \$21 pfet L=6U W=15U AS=13.5P AD=13.5P PS=31.8U PD=31.8U
* device instance $76 r0 *1 87.2,240.795 pfet
M$76 \$19 \$11 vdd \$21 pfet L=6U W=15U AS=13.5P AD=13.5P PS=31.8U PD=31.8U
* device instance $77 r0 *1 95.5,240.795 pfet
M$77 \$20 \$11 vdd \$21 pfet L=6U W=15U AS=13.5P AD=13.5P PS=31.8U PD=31.8U
* device instance $78 r0 *1 103.8,240.795 pfet
M$78 \$20 \$11 vdd \$21 pfet L=6U W=15U AS=13.5P AD=13.5P PS=31.8U PD=31.8U
* device instance $79 r0 *1 112.1,240.795 pfet
M$79 \$19 \$11 vdd \$21 pfet L=6U W=15U AS=13.5P AD=13.5P PS=31.8U PD=31.8U
* device instance $80 r0 *1 120.4,240.795 pfet
M$80 \$18 \$11 vdd \$21 pfet L=6U W=15U AS=13.5P AD=13.5P PS=31.8U PD=31.8U
* device instance $81 r0 *1 128.7,234.295 pfet
M$81 vdd vdd vdd \$21 pfet L=6U W=2U AS=1.8P AD=1.8P PS=5.8U PD=5.8U
.ENDS bandgap_top
