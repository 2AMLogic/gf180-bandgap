* extracted by klt extract --deck gf180mcu

* cell bandgap_top
* pin vdd
* pin vref
* pin vss
* pin vsubs
.SUBCKT bandgap_top vdd vref vss vsubs
* device instance $1 r0 *1 18.8,74.363 nfet
M$1 \$3 \$3 vss vsubs nfet L=2U W=2.5U AS=2.25P AD=2.25P PS=6.8U PD=6.8U
* device instance $2 r0 *1 23.1,75.613 nfet
M$2 \$4 \$3 vss vsubs nfet L=2U W=5U AS=4.5P AD=4.5P PS=11.8U PD=11.8U
* device instance $3 r0 *1 27.4,78.113 nfet
M$3 \$5 \$3 vss vsubs nfet L=2U W=10U AS=9P AD=9P PS=21.8U PD=21.8U
* device instance $4 r0 *1 31.7,78.113 nfet
M$4 \$5 \$3 vss vsubs nfet L=2U W=10U AS=9P AD=9P PS=21.8U PD=21.8U
* device instance $5 r0 *1 36,74.113 nfet
M$5 \$12 \$5 vss vsubs nfet L=2U W=2U AS=1.8P AD=1.8P PS=5.8U PD=5.8U
* device instance $6 r0 *1 40.3,74.113 nfet
M$6 \$4 \$5 vss vsubs nfet L=2U W=2U AS=1.8P AD=1.8P PS=5.8U PD=5.8U
* device instance $7 r0 *1 19.8,93.273 nfet
M$7 \$13 \$3 vss vsubs nfet L=4U W=10U AS=9P AD=9P PS=21.8U PD=21.8U
* device instance $8 r0 *1 25.8,105.073 nfet
M$8 vss vss vss vsubs nfet L=16U W=2U AS=1.8P AD=1.8P PS=5.8U PD=5.8U
* device instance $9 r0 *1 32.1,89.273 nfet
M$9 \$6 \$3 vss vsubs nfet L=16U W=2U AS=1.8P AD=1.8P PS=5.8U PD=5.8U
* device instance $10 r0 *1 44.1,109.073 nfet
M$10 \$10 \$8 \$9 vsubs nfet L=16U W=10U AS=9P AD=9P PS=21.8U PD=21.8U
* device instance $11 r0 *1 44.4,88.773 nfet
M$11 \$8 \$8 \$7 vsubs nfet L=4U W=1U AS=0.9P AD=0.9P PS=3.8U PD=3.8U
* device instance $12 r0 *1 50.7,88.773 nfet
M$12 \$7 \$7 vss vsubs nfet L=4U W=1U AS=0.9P AD=0.9P PS=3.8U PD=3.8U
* device instance $13 r0 *1 62.4,109.073 nfet
M$13 \$12 \$8 \$11 vsubs nfet L=16U W=10U AS=9P AD=9P PS=21.8U PD=21.8U
* device instance $14 r0 *1 80.7,109.073 nfet
M$14 \$12 \$8 \$11 vsubs nfet L=16U W=10U AS=9P AD=9P PS=21.8U PD=21.8U
* device instance $15 r0 *1 99,109.073 nfet
M$15 \$10 \$8 \$9 vsubs nfet L=16U W=10U AS=9P AD=9P PS=21.8U PD=21.8U
* device instance $16 r0 *1 117.3,105.073 nfet
M$16 vss vss vss vsubs nfet L=16U W=2U AS=1.8P AD=1.8P PS=5.8U PD=5.8U
* device instance $17 r0 *1 20.8,120.873 nfet
M$17 vss vss vss vsubs nfet L=6U W=2U AS=1.8P AD=1.8P PS=5.8U PD=5.8U
* device instance $18 r0 *1 29.1,132.373 nfet
M$18 \$9 \$20 \$13 vsubs nfet L=6U W=25U AS=22.5P AD=22.5P PS=51.8U PD=51.8U
* device instance $19 r0 *1 37.4,132.373 nfet
M$19 \$11 \$18 \$13 vsubs nfet L=6U W=25U AS=22.5P AD=22.5P PS=51.8U PD=51.8U
* device instance $20 r0 *1 45.7,132.373 nfet
M$20 \$11 \$18 \$13 vsubs nfet L=6U W=25U AS=22.5P AD=22.5P PS=51.8U PD=51.8U
* device instance $21 r0 *1 54,132.373 nfet
M$21 \$9 \$20 \$13 vsubs nfet L=6U W=25U AS=22.5P AD=22.5P PS=51.8U PD=51.8U
* device instance $22 r0 *1 62.3,132.373 nfet
M$22 \$9 \$20 \$13 vsubs nfet L=6U W=25U AS=22.5P AD=22.5P PS=51.8U PD=51.8U
* device instance $23 r0 *1 70.6,132.373 nfet
M$23 \$11 \$18 \$13 vsubs nfet L=6U W=25U AS=22.5P AD=22.5P PS=51.8U PD=51.8U
* device instance $24 r0 *1 78.9,132.373 nfet
M$24 \$11 \$18 \$13 vsubs nfet L=6U W=25U AS=22.5P AD=22.5P PS=51.8U PD=51.8U
* device instance $25 r0 *1 87.2,132.373 nfet
M$25 \$9 \$20 \$13 vsubs nfet L=6U W=25U AS=22.5P AD=22.5P PS=51.8U PD=51.8U
* device instance $26 r0 *1 95.5,132.373 nfet
M$26 \$9 \$20 \$13 vsubs nfet L=6U W=25U AS=22.5P AD=22.5P PS=51.8U PD=51.8U
* device instance $27 r0 *1 103.8,132.373 nfet
M$27 \$11 \$18 \$13 vsubs nfet L=6U W=25U AS=22.5P AD=22.5P PS=51.8U PD=51.8U
* device instance $28 r0 *1 112.1,132.373 nfet
M$28 \$11 \$18 \$13 vsubs nfet L=6U W=25U AS=22.5P AD=22.5P PS=51.8U PD=51.8U
* device instance $29 r0 *1 120.4,132.373 nfet
M$29 \$9 \$20 \$13 vsubs nfet L=6U W=25U AS=22.5P AD=22.5P PS=51.8U PD=51.8U
* device instance $30 r0 *1 128.7,132.373 nfet
M$30 \$9 \$20 \$13 vsubs nfet L=6U W=25U AS=22.5P AD=22.5P PS=51.8U PD=51.8U
* device instance $31 r0 *1 137,132.373 nfet
M$31 \$11 \$18 \$13 vsubs nfet L=6U W=25U AS=22.5P AD=22.5P PS=51.8U PD=51.8U
* device instance $32 r0 *1 145.3,132.373 nfet
M$32 \$11 \$18 \$13 vsubs nfet L=6U W=25U AS=22.5P AD=22.5P PS=51.8U PD=51.8U
* device instance $33 r0 *1 153.6,132.373 nfet
M$33 \$9 \$20 \$13 vsubs nfet L=6U W=25U AS=22.5P AD=22.5P PS=51.8U PD=51.8U
* device instance $34 r0 *1 161.9,132.373 nfet
M$34 \$9 \$20 \$13 vsubs nfet L=6U W=25U AS=22.5P AD=22.5P PS=51.8U PD=51.8U
* device instance $35 r0 *1 170.2,132.373 nfet
M$35 \$11 \$18 \$13 vsubs nfet L=6U W=25U AS=22.5P AD=22.5P PS=51.8U PD=51.8U
* device instance $36 r0 *1 178.5,132.373 nfet
M$36 \$11 \$18 \$13 vsubs nfet L=6U W=25U AS=22.5P AD=22.5P PS=51.8U PD=51.8U
* device instance $37 r0 *1 186.8,132.373 nfet
M$37 \$9 \$20 \$13 vsubs nfet L=6U W=25U AS=22.5P AD=22.5P PS=51.8U PD=51.8U
* device instance $38 r0 *1 195.1,132.373 nfet
M$38 \$9 \$20 \$13 vsubs nfet L=6U W=25U AS=22.5P AD=22.5P PS=51.8U PD=51.8U
* device instance $39 r0 *1 203.4,132.373 nfet
M$39 \$11 \$18 \$13 vsubs nfet L=6U W=25U AS=22.5P AD=22.5P PS=51.8U PD=51.8U
* device instance $40 r0 *1 211.7,132.373 nfet
M$40 \$11 \$18 \$13 vsubs nfet L=6U W=25U AS=22.5P AD=22.5P PS=51.8U PD=51.8U
* device instance $41 r0 *1 220,132.373 nfet
M$41 \$9 \$20 \$13 vsubs nfet L=6U W=25U AS=22.5P AD=22.5P PS=51.8U PD=51.8U
* device instance $42 r0 *1 228.3,120.873 nfet
M$42 vss vss vss vsubs nfet L=6U W=2U AS=1.8P AD=1.8P PS=5.8U PD=5.8U
* device instance $43 r0 *1 25.8,151.673 pfet
M$43 vdd vdd vdd \$33 pfet L=16U W=2U AS=1.8P AD=1.8P PS=5.8U PD=5.8U
* device instance $44 r0 *1 44.1,160.673 pfet
M$44 \$10 \$6 \$14 \$33 pfet L=16U W=20U AS=18P AD=18P PS=41.8U PD=41.8U
* device instance $45 r0 *1 62.4,160.673 pfet
M$45 \$12 \$6 \$15 \$33 pfet L=16U W=20U AS=18P AD=18P PS=41.8U PD=41.8U
* device instance $46 r0 *1 80.7,160.673 pfet
M$46 \$12 \$6 \$15 \$33 pfet L=16U W=20U AS=18P AD=18P PS=41.8U PD=41.8U
* device instance $47 r0 *1 99,160.673 pfet
M$47 \$10 \$6 \$14 \$33 pfet L=16U W=20U AS=18P AD=18P PS=41.8U PD=41.8U
* device instance $48 r0 *1 117.3,151.673 pfet
M$48 vdd vdd vdd \$33 pfet L=16U W=2U AS=1.8P AD=1.8P PS=5.8U PD=5.8U
* device instance $49 r0 *1 31,177.473 pfet
M$49 vdd vdd vdd \$33 pfet L=26.4U W=2U AS=1.8P AD=1.8P PS=5.8U PD=5.8U
* device instance $50 r0 *1 59.7,184.723 pfet
M$50 \$14 \$10 vdd \$33 pfet L=26.4U W=16.5U AS=14.85P AD=14.85P PS=34.8U
+ PD=34.8U
* device instance $51 r0 *1 88.4,184.723 pfet
M$51 \$15 \$10 vdd \$33 pfet L=26.4U W=16.5U AS=14.85P AD=14.85P PS=34.8U
+ PD=34.8U
* device instance $52 r0 *1 117.1,184.723 pfet
M$52 \$15 \$10 vdd \$33 pfet L=26.4U W=16.5U AS=14.85P AD=14.85P PS=34.8U
+ PD=34.8U
* device instance $53 r0 *1 145.8,184.723 pfet
M$53 \$14 \$10 vdd \$33 pfet L=26.4U W=16.5U AS=14.85P AD=14.85P PS=34.8U
+ PD=34.8U
* device instance $54 r0 *1 174.5,177.473 pfet
M$54 vdd vdd vdd \$33 pfet L=26.4U W=2U AS=1.8P AD=1.8P PS=5.8U PD=5.8U
* device instance $55 r0 *1 23.8,199.493 pfet
M$55 \$4 \$4 vdd \$33 pfet L=12U W=4U AS=3.6P AD=3.6P PS=9.8U PD=9.8U
* device instance $56 r0 *1 22.05,208.013 pfet
M$56 vdd vdd vdd \$33 pfet L=8.5U W=2U AS=1.8P AD=1.8P PS=5.8U PD=5.8U
* device instance $57 r0 *1 32.85,212.325 pfet
M$57 \$16 \$12 vdd \$33 pfet L=8.5U W=10.625U AS=9.5625P AD=9.5625P PS=23.05U
+ PD=23.05U
* device instance $58 r0 *1 57.1,197.993 pfet
M$58 \$6 \$6 vdd \$33 pfet L=50U W=1U AS=0.9P AD=0.9P PS=3.8U PD=3.8U
* device instance $59 r0 *1 43.65,212.325 pfet
M$59 \$3 \$4 \$16 \$33 pfet L=8.5U W=10.625U AS=9.5625P AD=9.5625P PS=23.05U
+ PD=23.05U
* device instance $60 r0 *1 54.45,208.013 pfet
M$60 vdd vdd vdd \$33 pfet L=8.5U W=2U AS=1.8P AD=1.8P PS=5.8U PD=5.8U
* device instance $61 r0 *1 109.4,199.993 pfet
M$61 \$8 \$6 vdd \$33 pfet L=50U W=5U AS=4.5P AD=4.5P PS=11.8U PD=11.8U
* device instance $62 r0 *1 22.05,223.798 pfet
M$62 vdd vdd vdd \$33 pfet L=8.5U W=2U AS=1.8P AD=1.8P PS=5.8U PD=5.8U
* device instance $63 r0 *1 32.85,233.423 pfet
M$63 \$18 \$4 \$17 \$33 pfet L=8.5U W=21.25U AS=19.125P AD=19.125P PS=44.3U
+ PD=44.3U
* device instance $64 r0 *1 43.65,233.423 pfet
M$64 \$20 \$4 \$19 \$33 pfet L=8.5U W=21.25U AS=19.125P AD=19.125P PS=44.3U
+ PD=44.3U
* device instance $65 r0 *1 54.45,233.423 pfet
M$65 vref \$4 \$21 \$33 pfet L=8.5U W=21.25U AS=19.125P AD=19.125P PS=44.3U
+ PD=44.3U
* device instance $66 r0 *1 65.25,233.423 pfet
M$66 vref \$4 \$21 \$33 pfet L=8.5U W=21.25U AS=19.125P AD=19.125P PS=44.3U
+ PD=44.3U
* device instance $67 r0 *1 76.05,233.423 pfet
M$67 \$20 \$4 \$19 \$33 pfet L=8.5U W=21.25U AS=19.125P AD=19.125P PS=44.3U
+ PD=44.3U
* device instance $68 r0 *1 86.85,233.423 pfet
M$68 \$18 \$4 \$17 \$33 pfet L=8.5U W=21.25U AS=19.125P AD=19.125P PS=44.3U
+ PD=44.3U
* device instance $69 r0 *1 97.65,233.423 pfet
M$69 \$18 \$4 \$17 \$33 pfet L=8.5U W=21.25U AS=19.125P AD=19.125P PS=44.3U
+ PD=44.3U
* device instance $70 r0 *1 108.45,233.423 pfet
M$70 \$20 \$4 \$19 \$33 pfet L=8.5U W=21.25U AS=19.125P AD=19.125P PS=44.3U
+ PD=44.3U
* device instance $71 r0 *1 119.25,233.423 pfet
M$71 vref \$4 \$21 \$33 pfet L=8.5U W=21.25U AS=19.125P AD=19.125P PS=44.3U
+ PD=44.3U
* device instance $72 r0 *1 130.05,233.423 pfet
M$72 vref \$4 \$21 \$33 pfet L=8.5U W=21.25U AS=19.125P AD=19.125P PS=44.3U
+ PD=44.3U
* device instance $73 r0 *1 140.85,233.423 pfet
M$73 \$20 \$4 \$19 \$33 pfet L=8.5U W=21.25U AS=19.125P AD=19.125P PS=44.3U
+ PD=44.3U
* device instance $74 r0 *1 151.65,233.423 pfet
M$74 \$18 \$4 \$17 \$33 pfet L=8.5U W=21.25U AS=19.125P AD=19.125P PS=44.3U
+ PD=44.3U
* device instance $75 r0 *1 162.45,223.798 pfet
M$75 vdd vdd vdd \$33 pfet L=8.5U W=2U AS=1.8P AD=1.8P PS=5.8U PD=5.8U
* device instance $76 r0 *1 22.05,252.128 pfet
M$76 vdd vdd vdd \$33 pfet L=8.5U W=2U AS=1.8P AD=1.8P PS=5.8U PD=5.8U
* device instance $77 r0 *1 32.85,261.753 pfet
M$77 \$17 \$12 vdd \$33 pfet L=8.5U W=21.25U AS=19.125P AD=19.125P PS=44.3U
+ PD=44.3U
* device instance $78 r0 *1 43.65,261.753 pfet
M$78 \$19 \$12 vdd \$33 pfet L=8.5U W=21.25U AS=19.125P AD=19.125P PS=44.3U
+ PD=44.3U
* device instance $79 r0 *1 54.45,261.753 pfet
M$79 \$21 \$12 vdd \$33 pfet L=8.5U W=21.25U AS=19.125P AD=19.125P PS=44.3U
+ PD=44.3U
* device instance $80 r0 *1 65.25,261.753 pfet
M$80 \$21 \$12 vdd \$33 pfet L=8.5U W=21.25U AS=19.125P AD=19.125P PS=44.3U
+ PD=44.3U
* device instance $81 r0 *1 76.05,261.753 pfet
M$81 \$19 \$12 vdd \$33 pfet L=8.5U W=21.25U AS=19.125P AD=19.125P PS=44.3U
+ PD=44.3U
* device instance $82 r0 *1 86.85,261.753 pfet
M$82 \$17 \$12 vdd \$33 pfet L=8.5U W=21.25U AS=19.125P AD=19.125P PS=44.3U
+ PD=44.3U
* device instance $83 r0 *1 97.65,261.753 pfet
M$83 \$17 \$12 vdd \$33 pfet L=8.5U W=21.25U AS=19.125P AD=19.125P PS=44.3U
+ PD=44.3U
* device instance $84 r0 *1 108.45,261.753 pfet
M$84 \$19 \$12 vdd \$33 pfet L=8.5U W=21.25U AS=19.125P AD=19.125P PS=44.3U
+ PD=44.3U
* device instance $85 r0 *1 119.25,261.753 pfet
M$85 \$21 \$12 vdd \$33 pfet L=8.5U W=21.25U AS=19.125P AD=19.125P PS=44.3U
+ PD=44.3U
* device instance $86 r0 *1 130.05,261.753 pfet
M$86 \$21 \$12 vdd \$33 pfet L=8.5U W=21.25U AS=19.125P AD=19.125P PS=44.3U
+ PD=44.3U
* device instance $87 r0 *1 140.85,261.753 pfet
M$87 \$19 \$12 vdd \$33 pfet L=8.5U W=21.25U AS=19.125P AD=19.125P PS=44.3U
+ PD=44.3U
* device instance $88 r0 *1 151.65,261.753 pfet
M$88 \$17 \$12 vdd \$33 pfet L=8.5U W=21.25U AS=19.125P AD=19.125P PS=44.3U
+ PD=44.3U
* device instance $89 r0 *1 162.45,252.128 pfet
M$89 vdd vdd vdd \$33 pfet L=8.5U W=2U AS=1.8P AD=1.8P PS=5.8U PD=5.8U
* device instance $90 r0 *1 24.2,289.038 bjt
Q$90 vsubs \$23 vss bjt AE=25P PE=20U AB=108.16P PB=41.6U AC=108.16P PC=41.6U
+ NE=1
* device instance $91 r0 *1 39.3,289.038 bjt
Q$91 vsubs \$24 \$25 bjt AE=25P PE=20U AB=108.16P PB=41.6U AC=108.16P PC=41.6U
+ NE=1
* device instance $92 r0 *1 54.4,289.038 bjt
Q$92 vsubs \$26 \$27 bjt AE=25P PE=20U AB=108.16P PB=41.6U AC=108.16P PC=41.6U
+ NE=1
* device instance $93 r0 *1 69.5,289.038 bjt
Q$93 vsubs \$28 \$27 bjt AE=25P PE=20U AB=108.16P PB=41.6U AC=108.16P PC=41.6U
+ NE=1
* device instance $94 r0 *1 84.6,289.038 bjt
Q$94 vsubs \$29 \$18 bjt AE=25P PE=20U AB=108.16P PB=41.6U AC=108.16P PC=41.6U
+ NE=1
* device instance $95 r0 *1 99.7,289.038 bjt
Q$95 vsubs \$30 \$27 bjt AE=25P PE=20U AB=108.16P PB=41.6U AC=108.16P PC=41.6U
+ NE=1
* device instance $96 r0 *1 114.8,289.038 bjt
Q$96 vsubs \$31 \$27 bjt AE=25P PE=20U AB=108.16P PB=41.6U AC=108.16P PC=41.6U
+ NE=1
* device instance $97 r0 *1 129.9,289.038 bjt
Q$97 vsubs \$32 vss bjt AE=25P PE=20U AB=108.16P PB=41.6U AC=108.16P PC=41.6U
+ NE=1
* device instance $98 r0 *1 46.9,149.873 cap_mim_2f0_m4m5_noshield
C$98 vdd \$12 6.93635376e-12 cap_mim_2f0_m4m5_noshield
* device instance $99 r0 *1 21.35,305.138 ppolyf_u
R$99 \$27 \$20 vsubs 6359.5 ppolyf_u
* device instance $100 r0 *1 58.35,308.524 ppolyf_u
R$100 \$25 \$60 vsubs 77594.3 ppolyf_u
* device instance $101 r0 *1 18.726,321.91 ppolyf_u
R$101 \$60 \$60 vsubs 485.1 ppolyf_u
* device instance $102 r0 *1 22.678,321.91 ppolyf_u
R$102 \$60 \$34 vsubs 485.1 ppolyf_u
* device instance $103 r0 *1 26.63,321.91 ppolyf_u
R$103 \$34 \$60 vsubs 485.1 ppolyf_u
* device instance $104 r0 *1 30.582,321.91 ppolyf_u
R$104 \$60 \$35 vsubs 485.1 ppolyf_u
* device instance $105 r0 *1 34.534,321.91 ppolyf_u
R$105 \$35 \$36 vsubs 485.1 ppolyf_u
* device instance $106 r0 *1 38.486,321.91 ppolyf_u
R$106 \$36 \$37 vsubs 485.1 ppolyf_u
* device instance $107 r0 *1 42.438,321.91 ppolyf_u
R$107 \$37 \$60 vsubs 485.1 ppolyf_u
* device instance $108 r0 *1 46.39,321.91 ppolyf_u
R$108 \$60 \$38 vsubs 485.1 ppolyf_u
* device instance $109 r0 *1 50.342,321.91 ppolyf_u
R$109 \$38 \$39 vsubs 485.1 ppolyf_u
* device instance $110 r0 *1 54.294,321.91 ppolyf_u
R$110 \$39 \$40 vsubs 485.1 ppolyf_u
* device instance $111 r0 *1 58.246,321.91 ppolyf_u
R$111 \$40 \$41 vsubs 485.1 ppolyf_u
* device instance $112 r0 *1 62.198,321.91 ppolyf_u
R$112 \$41 \$42 vsubs 485.1 ppolyf_u
* device instance $113 r0 *1 66.15,321.91 ppolyf_u
R$113 \$42 \$43 vsubs 485.1 ppolyf_u
* device instance $114 r0 *1 70.102,321.91 ppolyf_u
R$114 \$43 \$44 vsubs 485.1 ppolyf_u
* device instance $115 r0 *1 74.054,321.91 ppolyf_u
R$115 \$44 \$60 vsubs 485.1 ppolyf_u
* device instance $116 r0 *1 78.006,321.91 ppolyf_u
R$116 \$60 \$45 vsubs 485.1 ppolyf_u
* device instance $117 r0 *1 81.958,321.91 ppolyf_u
R$117 \$45 \$46 vsubs 485.1 ppolyf_u
* device instance $118 r0 *1 85.91,321.91 ppolyf_u
R$118 \$46 \$47 vsubs 485.1 ppolyf_u
* device instance $119 r0 *1 89.862,321.91 ppolyf_u
R$119 \$47 \$48 vsubs 485.1 ppolyf_u
* device instance $120 r0 *1 93.814,321.91 ppolyf_u
R$120 \$48 \$49 vsubs 485.1 ppolyf_u
* device instance $121 r0 *1 97.766,321.91 ppolyf_u
R$121 \$49 \$50 vsubs 485.1 ppolyf_u
* device instance $122 r0 *1 101.718,321.91 ppolyf_u
R$122 \$50 \$51 vsubs 485.1 ppolyf_u
* device instance $123 r0 *1 105.67,321.91 ppolyf_u
R$123 \$51 \$52 vsubs 485.1 ppolyf_u
* device instance $124 r0 *1 109.622,321.91 ppolyf_u
R$124 \$52 \$53 vsubs 485.1 ppolyf_u
* device instance $125 r0 *1 113.574,321.91 ppolyf_u
R$125 \$53 \$54 vsubs 485.1 ppolyf_u
* device instance $126 r0 *1 117.526,321.91 ppolyf_u
R$126 \$54 \$55 vsubs 485.1 ppolyf_u
* device instance $127 r0 *1 121.478,321.91 ppolyf_u
R$127 \$55 \$56 vsubs 485.1 ppolyf_u
* device instance $128 r0 *1 125.43,321.91 ppolyf_u
R$128 \$56 \$57 vsubs 485.1 ppolyf_u
* device instance $129 r0 *1 129.382,321.91 ppolyf_u
R$129 \$57 \$58 vsubs 485.1 ppolyf_u
* device instance $130 r0 *1 133.334,321.91 ppolyf_u
R$130 \$58 \$59 vsubs 485.1 ppolyf_u
* device instance $131 r0 *1 137.286,321.91 ppolyf_u
R$131 \$59 \$60 vsubs 485.1 ppolyf_u
* device instance $132 r0 *1 20.726,327.51 ppolyf_u
R$132 vref \$61 vsubs 485.1 ppolyf_u
* device instance $133 r0 *1 24.678,327.51 ppolyf_u
R$133 \$61 \$62 vsubs 485.1 ppolyf_u
* device instance $134 r0 *1 28.63,327.51 ppolyf_u
R$134 \$62 \$63 vsubs 485.1 ppolyf_u
* device instance $135 r0 *1 32.582,327.51 ppolyf_u
R$135 \$63 \$64 vsubs 485.1 ppolyf_u
* device instance $136 r0 *1 36.534,327.51 ppolyf_u
R$136 \$64 \$65 vsubs 485.1 ppolyf_u
* device instance $137 r0 *1 40.486,327.51 ppolyf_u
R$137 \$65 \$66 vsubs 485.1 ppolyf_u
* device instance $138 r0 *1 44.438,327.51 ppolyf_u
R$138 \$66 \$67 vsubs 485.1 ppolyf_u
* device instance $139 r0 *1 48.39,327.51 ppolyf_u
R$139 \$67 \$68 vsubs 485.1 ppolyf_u
* device instance $140 r0 *1 52.342,327.51 ppolyf_u
R$140 \$68 \$69 vsubs 485.1 ppolyf_u
* device instance $141 r0 *1 56.294,327.51 ppolyf_u
R$141 \$69 \$70 vsubs 485.1 ppolyf_u
* device instance $142 r0 *1 60.246,327.51 ppolyf_u
R$142 \$70 \$71 vsubs 485.1 ppolyf_u
* device instance $143 r0 *1 64.198,327.51 ppolyf_u
R$143 \$71 \$72 vsubs 485.1 ppolyf_u
* device instance $144 r0 *1 68.15,327.51 ppolyf_u
R$144 \$72 \$73 vsubs 485.1 ppolyf_u
* device instance $145 r0 *1 72.102,327.51 ppolyf_u
R$145 \$73 \$74 vsubs 485.1 ppolyf_u
* device instance $146 r0 *1 76.054,327.51 ppolyf_u
R$146 \$74 \$75 vsubs 485.1 ppolyf_u
* device instance $147 r0 *1 80.006,327.51 ppolyf_u
R$147 \$75 \$76 vsubs 485.1 ppolyf_u
* device instance $148 r0 *1 83.958,327.51 ppolyf_u
R$148 \$76 \$77 vsubs 485.1 ppolyf_u
* device instance $149 r0 *1 87.91,327.51 ppolyf_u
R$149 \$77 \$78 vsubs 485.1 ppolyf_u
* device instance $150 r0 *1 91.862,327.51 ppolyf_u
R$150 \$78 \$79 vsubs 485.1 ppolyf_u
* device instance $151 r0 *1 95.814,327.51 ppolyf_u
R$151 \$79 \$80 vsubs 485.1 ppolyf_u
* device instance $152 r0 *1 99.766,327.51 ppolyf_u
R$152 \$80 \$81 vsubs 485.1 ppolyf_u
* device instance $153 r0 *1 103.718,327.51 ppolyf_u
R$153 \$81 \$82 vsubs 485.1 ppolyf_u
* device instance $154 r0 *1 107.67,327.51 ppolyf_u
R$154 \$82 \$83 vsubs 485.1 ppolyf_u
* device instance $155 r0 *1 111.622,327.51 ppolyf_u
R$155 \$83 \$84 vsubs 485.1 ppolyf_u
* device instance $156 r0 *1 115.574,327.51 ppolyf_u
R$156 \$84 \$85 vsubs 485.1 ppolyf_u
* device instance $157 r0 *1 119.526,327.51 ppolyf_u
R$157 \$85 \$86 vsubs 485.1 ppolyf_u
* device instance $158 r0 *1 123.478,327.51 ppolyf_u
R$158 \$86 \$87 vsubs 485.1 ppolyf_u
* device instance $159 r0 *1 127.43,327.51 ppolyf_u
R$159 \$87 \$88 vsubs 485.1 ppolyf_u
* device instance $160 r0 *1 131.382,327.51 ppolyf_u
R$160 \$88 \$89 vsubs 485.1 ppolyf_u
* device instance $161 r0 *1 135.334,327.51 ppolyf_u
R$161 \$89 \$90 vsubs 485.1 ppolyf_u
* device instance $162 r0 *1 139.286,327.51 ppolyf_u
R$162 \$90 \$91 vsubs 485.1 ppolyf_u
* device instance $163 r0 *1 143.238,327.51 ppolyf_u
R$163 \$91 \$60 vsubs 485.1 ppolyf_u
* device instance $164 r0 *1 82.3,34.936 ppolyf_u_1k
R$164 \$5 vdd vsubs 1999980.5 ppolyf_u_1k
.ENDS bandgap_top
