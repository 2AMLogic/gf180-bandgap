* TIE-AWARE variant of bandgap_top.ref.spice -- GENERATED by
* layout/lvs/tie_reference.py (gf180-bandgap#378), do not edit.
* vsubs -> vss, nwl -> vdd, nw_<unit> -> vss: the ties klt >= 0.3.0 recognises.
* LVS reference netlist for bandgap_top -- GENERATED, do not edit.
*
* Produced by layout/lvs/make_reference.py from
* design/netlist/bandgap_top.spice + layout/bandgap_top/plan.py. See
* that script's docstring for the nine mechanical transformations
* applied and why each one is a klt-extraction-deck capability (or a
* drawn-decomposition) consequence rather than a design
* simplification.
*
* drawn trim code : 32
* MOS devices     : 42 nfet + 47 pfet (14 of them edge dummies)
* resistors       : 65 ppolyf_u + 1 ppolyf_u_1k
* bipolars        : 8 bjt (1 per drawn PNP unit -- see the docstring's step 8)
* capacitors      : 1 cap_mim_2f0_m4m5_noshield

.SUBCKT bandgap_top vdd vss vref
Camp_CC vdd fb 6.936354e-12 cap_mim_2f0_m4m5_noshield a=3.457440e-09 p=2.352000e-04
Mamp_M1_0 amp_n1 sns2 amp_tail vss nfet L=6U W=25U
Mamp_M1_1 amp_n1 sns2 amp_tail vss nfet L=6U W=25U
Mamp_M1_10 amp_n1 sns2 amp_tail vss nfet L=6U W=25U
Mamp_M1_11 amp_n1 sns2 amp_tail vss nfet L=6U W=25U
Mamp_M1_2 amp_n1 sns2 amp_tail vss nfet L=6U W=25U
Mamp_M1_3 amp_n1 sns2 amp_tail vss nfet L=6U W=25U
Mamp_M1_4 amp_n1 sns2 amp_tail vss nfet L=6U W=25U
Mamp_M1_5 amp_n1 sns2 amp_tail vss nfet L=6U W=25U
Mamp_M1_6 amp_n1 sns2 amp_tail vss nfet L=6U W=25U
Mamp_M1_7 amp_n1 sns2 amp_tail vss nfet L=6U W=25U
Mamp_M1_8 amp_n1 sns2 amp_tail vss nfet L=6U W=25U
Mamp_M1_9 amp_n1 sns2 amp_tail vss nfet L=6U W=25U
Mamp_M2_0 amp_n2 sns1 amp_tail vss nfet L=6U W=25U
Mamp_M2_1 amp_n2 sns1 amp_tail vss nfet L=6U W=25U
Mamp_M2_10 amp_n2 sns1 amp_tail vss nfet L=6U W=25U
Mamp_M2_11 amp_n2 sns1 amp_tail vss nfet L=6U W=25U
Mamp_M2_2 amp_n2 sns1 amp_tail vss nfet L=6U W=25U
Mamp_M2_3 amp_n2 sns1 amp_tail vss nfet L=6U W=25U
Mamp_M2_4 amp_n2 sns1 amp_tail vss nfet L=6U W=25U
Mamp_M2_5 amp_n2 sns1 amp_tail vss nfet L=6U W=25U
Mamp_M2_6 amp_n2 sns1 amp_tail vss nfet L=6U W=25U
Mamp_M2_7 amp_n2 sns1 amp_tail vss nfet L=6U W=25U
Mamp_M2_8 amp_n2 sns1 amp_tail vss nfet L=6U W=25U
Mamp_M2_9 amp_n2 sns1 amp_tail vss nfet L=6U W=25U
Mamp_M3_0 amp_a3 amp_nd1 vdd vdd pfet L=26.4U W=16.5U
Mamp_M3_1 amp_a3 amp_nd1 vdd vdd pfet L=26.4U W=16.5U
Mamp_M4_0 amp_a4 amp_nd1 vdd vdd pfet L=26.4U W=16.5U
Mamp_M4_1 amp_a4 amp_nd1 vdd vdd pfet L=26.4U W=16.5U
Mamp_M5_0 amp_tail ibias vss vss nfet L=4U W=10U
Mamp_MB1_0 amp_ncasc amp_pbias vdd vdd pfet L=50U W=5U
Mamp_MBD1_0 amp_ncasc amp_ncasc amp_nb1 vss nfet L=4U W=1U
Mamp_MBD2_0 amp_nb1 amp_nb1 vss vss nfet L=4U W=1U
Mamp_MBN2_0 amp_pbias ibias vss vss nfet L=16U W=2U
Mamp_MBP1_0 amp_pbias amp_pbias vdd vdd pfet L=50U W=1U
Mamp_MC1_0 amp_nd1 amp_ncasc amp_n1 vss nfet L=16U W=10U
Mamp_MC1_1 amp_nd1 amp_ncasc amp_n1 vss nfet L=16U W=10U
Mamp_MC2_0 fb amp_ncasc amp_n2 vss nfet L=16U W=10U
Mamp_MC2_1 fb amp_ncasc amp_n2 vss nfet L=16U W=10U
Mamp_MC3_0 amp_nd1 amp_pbias amp_a3 vdd pfet L=16U W=20U
Mamp_MC3_1 amp_nd1 amp_pbias amp_a3 vdd pfet L=16U W=20U
Mamp_MC4_0 fb amp_pbias amp_a4 vdd pfet L=16U W=20U
Mamp_MC4_1 fb amp_pbias amp_a4 vdd pfet L=16U W=20U
Mcore_M1_0 core_d1 fb vdd vdd pfet L=8.5U W=21.25U
Mcore_M1_1 core_d1 fb vdd vdd pfet L=8.5U W=21.25U
Mcore_M1_2 core_d1 fb vdd vdd pfet L=8.5U W=21.25U
Mcore_M1_3 core_d1 fb vdd vdd pfet L=8.5U W=21.25U
Mcore_M2_0 core_d2 fb vdd vdd pfet L=8.5U W=21.25U
Mcore_M2_1 core_d2 fb vdd vdd pfet L=8.5U W=21.25U
Mcore_M2_2 core_d2 fb vdd vdd pfet L=8.5U W=21.25U
Mcore_M2_3 core_d2 fb vdd vdd pfet L=8.5U W=21.25U
Mcore_M3_0 core_d3 fb vdd vdd pfet L=8.5U W=21.25U
Mcore_M3_1 core_d3 fb vdd vdd pfet L=8.5U W=21.25U
Mcore_M3_2 core_d3 fb vdd vdd pfet L=8.5U W=21.25U
Mcore_M3_3 core_d3 fb vdd vdd pfet L=8.5U W=21.25U
Mcore_M4_0 core_d4 fb vdd vdd pfet L=8.5U W=10.625U
Mcore_M5_0 ibias ibias vss vss nfet L=2U W=2.5U
Mcore_MC1_0 sns1 casc core_d1 vdd pfet L=8.5U W=21.25U
Mcore_MC1_1 sns1 casc core_d1 vdd pfet L=8.5U W=21.25U
Mcore_MC1_2 sns1 casc core_d1 vdd pfet L=8.5U W=21.25U
Mcore_MC1_3 sns1 casc core_d1 vdd pfet L=8.5U W=21.25U
Mcore_MC2_0 sns2 casc core_d2 vdd pfet L=8.5U W=21.25U
Mcore_MC2_1 sns2 casc core_d2 vdd pfet L=8.5U W=21.25U
Mcore_MC2_2 sns2 casc core_d2 vdd pfet L=8.5U W=21.25U
Mcore_MC2_3 sns2 casc core_d2 vdd pfet L=8.5U W=21.25U
Mcore_MC3_0 vref casc core_d3 vdd pfet L=8.5U W=21.25U
Mcore_MC3_1 vref casc core_d3 vdd pfet L=8.5U W=21.25U
Mcore_MC3_2 vref casc core_d3 vdd pfet L=8.5U W=21.25U
Mcore_MC3_3 vref casc core_d3 vdd pfet L=8.5U W=21.25U
Mcore_MC4_0 ibias casc core_d4 vdd pfet L=8.5U W=10.625U
Mcore_MCB_0 casc casc vdd vdd pfet L=12U W=4U
Mcore_MNB_0 casc ibias vss vss nfet L=2U W=5U
Mdum_ampload_l vdd vdd vdd vdd pfet L=26.4U W=2U
Mdum_ampload_r vdd vdd vdd vdd pfet L=26.4U W=2U
Mdum_ampncasc_l vss vss vss vss nfet L=16U W=2U
Mdum_ampncasc_r vss vss vss vss nfet L=16U W=2U
Mdum_amppair_l vss vss vss vss nfet L=6U W=2U
Mdum_amppair_r vss vss vss vss nfet L=6U W=2U
Mdum_amppcasc_l vdd vdd vdd vdd pfet L=16U W=2U
Mdum_amppcasc_r vdd vdd vdd vdd pfet L=16U W=2U
Mdum_corecasc_l vdd vdd vdd vdd pfet L=8.5U W=2U
Mdum_corecasc_r vdd vdd vdd vdd pfet L=8.5U W=2U
Mdum_coreibias_l vdd vdd vdd vdd pfet L=8.5U W=2U
Mdum_coreibias_r vdd vdd vdd vdd pfet L=8.5U W=2U
Mdum_coremirror_l vdd vdd vdd vdd pfet L=8.5U W=2U
Mdum_coremirror_r vdd vdd vdd vdd pfet L=8.5U W=2U
Mstartup_MKCASC_0 casc startup_det vss vss nfet L=2U W=2U
Mstartup_MKFB_0 fb startup_det vss vss nfet L=2U W=2U
Mstartup_MSENSE_0 startup_det ibias vss vss nfet L=2U W=10U
Mstartup_MSENSE_1 startup_det ibias vss vss nfet L=2U W=10U
Qcore_Q1 vss vss sns1 bjt AE=2.500000e-11 PE=2.000000e-05 AB=1.081600e-10 PB=4.160000e-05 AC=1.081600e-10 PC=4.160000e-05
Qcore_Q2_0 vss vss core_e2 bjt AE=2.500000e-11 PE=2.000000e-05 AB=1.081600e-10 PB=4.160000e-05 AC=1.081600e-10 PC=4.160000e-05
Qcore_Q2_1 vss vss core_e2 bjt AE=2.500000e-11 PE=2.000000e-05 AB=1.081600e-10 PB=4.160000e-05 AC=1.081600e-10 PC=4.160000e-05
Qcore_Q2_2 vss vss core_e2 bjt AE=2.500000e-11 PE=2.000000e-05 AB=1.081600e-10 PB=4.160000e-05 AC=1.081600e-10 PC=4.160000e-05
Qcore_Q2_3 vss vss core_e2 bjt AE=2.500000e-11 PE=2.000000e-05 AB=1.081600e-10 PB=4.160000e-05 AC=1.081600e-10 PC=4.160000e-05
Qcore_Q3 vss vss core_e3 bjt AE=2.500000e-11 PE=2.000000e-05 AB=1.081600e-10 PB=4.160000e-05 AC=1.081600e-10 PC=4.160000e-05
Qdum_pnp_l vss vss vss bjt AE=2.500000e-11 PE=2.000000e-05 AB=1.081600e-10 PB=4.160000e-05 AC=1.081600e-10 PC=4.160000e-05
Qdum_pnp_r vss vss vss bjt AE=2.500000e-11 PE=2.000000e-05 AB=1.081600e-10 PB=4.160000e-05 AC=1.081600e-10 PC=4.160000e-05
Rcore_R1 core_e3 core_tn0 vss 77594.300000 ppolyf_u
Rcore_R2 core_e2 sns2 vss 6359.500000 ppolyf_u
Rcore_trim_RU0 core_tn0 core_tn0 vss 485.100000 ppolyf_u
Rcore_trim_RU1 core_tn0 core_trim_u1_0 vss 485.100000 ppolyf_u
Rcore_trim_RU10 core_trim_u3_2 core_trim_u3_3 vss 485.100000 ppolyf_u
Rcore_trim_RU11 core_trim_u3_3 core_trim_u3_4 vss 485.100000 ppolyf_u
Rcore_trim_RU12 core_trim_u3_4 core_trim_u3_5 vss 485.100000 ppolyf_u
Rcore_trim_RU13 core_trim_u3_5 core_trim_u3_6 vss 485.100000 ppolyf_u
Rcore_trim_RU14 core_trim_u3_6 core_tn0 vss 485.100000 ppolyf_u
Rcore_trim_RU15 core_tn0 core_trim_u4_0 vss 485.100000 ppolyf_u
Rcore_trim_RU16 core_trim_u4_0 core_trim_u4_1 vss 485.100000 ppolyf_u
Rcore_trim_RU17 core_trim_u4_1 core_trim_u4_2 vss 485.100000 ppolyf_u
Rcore_trim_RU18 core_trim_u4_2 core_trim_u4_3 vss 485.100000 ppolyf_u
Rcore_trim_RU19 core_trim_u4_3 core_trim_u4_4 vss 485.100000 ppolyf_u
Rcore_trim_RU2 core_trim_u1_0 core_tn0 vss 485.100000 ppolyf_u
Rcore_trim_RU20 core_trim_u4_4 core_trim_u4_5 vss 485.100000 ppolyf_u
Rcore_trim_RU21 core_trim_u4_5 core_trim_u4_6 vss 485.100000 ppolyf_u
Rcore_trim_RU22 core_trim_u4_6 core_trim_u4_7 vss 485.100000 ppolyf_u
Rcore_trim_RU23 core_trim_u4_7 core_trim_u4_8 vss 485.100000 ppolyf_u
Rcore_trim_RU24 core_trim_u4_8 core_trim_u4_9 vss 485.100000 ppolyf_u
Rcore_trim_RU25 core_trim_u4_9 core_trim_u4_10 vss 485.100000 ppolyf_u
Rcore_trim_RU26 core_trim_u4_10 core_trim_u4_11 vss 485.100000 ppolyf_u
Rcore_trim_RU27 core_trim_u4_11 core_trim_u4_12 vss 485.100000 ppolyf_u
Rcore_trim_RU28 core_trim_u4_12 core_trim_u4_13 vss 485.100000 ppolyf_u
Rcore_trim_RU29 core_trim_u4_13 core_trim_u4_14 vss 485.100000 ppolyf_u
Rcore_trim_RU3 core_tn0 core_trim_u2_0 vss 485.100000 ppolyf_u
Rcore_trim_RU30 core_trim_u4_14 core_tn0 vss 485.100000 ppolyf_u
Rcore_trim_RU31 core_tn0 core_trim_u5_0 vss 485.100000 ppolyf_u
Rcore_trim_RU32 core_trim_u5_0 core_trim_u5_1 vss 485.100000 ppolyf_u
Rcore_trim_RU33 core_trim_u5_1 core_trim_u5_2 vss 485.100000 ppolyf_u
Rcore_trim_RU34 core_trim_u5_2 core_trim_u5_3 vss 485.100000 ppolyf_u
Rcore_trim_RU35 core_trim_u5_3 core_trim_u5_4 vss 485.100000 ppolyf_u
Rcore_trim_RU36 core_trim_u5_4 core_trim_u5_5 vss 485.100000 ppolyf_u
Rcore_trim_RU37 core_trim_u5_5 core_trim_u5_6 vss 485.100000 ppolyf_u
Rcore_trim_RU38 core_trim_u5_6 core_trim_u5_7 vss 485.100000 ppolyf_u
Rcore_trim_RU39 core_trim_u5_7 core_trim_u5_8 vss 485.100000 ppolyf_u
Rcore_trim_RU4 core_trim_u2_0 core_trim_u2_1 vss 485.100000 ppolyf_u
Rcore_trim_RU40 core_trim_u5_8 core_trim_u5_9 vss 485.100000 ppolyf_u
Rcore_trim_RU41 core_trim_u5_9 core_trim_u5_10 vss 485.100000 ppolyf_u
Rcore_trim_RU42 core_trim_u5_10 core_trim_u5_11 vss 485.100000 ppolyf_u
Rcore_trim_RU43 core_trim_u5_11 core_trim_u5_12 vss 485.100000 ppolyf_u
Rcore_trim_RU44 core_trim_u5_12 core_trim_u5_13 vss 485.100000 ppolyf_u
Rcore_trim_RU45 core_trim_u5_13 core_trim_u5_14 vss 485.100000 ppolyf_u
Rcore_trim_RU46 core_trim_u5_14 core_trim_u5_15 vss 485.100000 ppolyf_u
Rcore_trim_RU47 core_trim_u5_15 core_trim_u5_16 vss 485.100000 ppolyf_u
Rcore_trim_RU48 core_trim_u5_16 core_trim_u5_17 vss 485.100000 ppolyf_u
Rcore_trim_RU49 core_trim_u5_17 core_trim_u5_18 vss 485.100000 ppolyf_u
Rcore_trim_RU5 core_trim_u2_1 core_trim_u2_2 vss 485.100000 ppolyf_u
Rcore_trim_RU50 core_trim_u5_18 core_trim_u5_19 vss 485.100000 ppolyf_u
Rcore_trim_RU51 core_trim_u5_19 core_trim_u5_20 vss 485.100000 ppolyf_u
Rcore_trim_RU52 core_trim_u5_20 core_trim_u5_21 vss 485.100000 ppolyf_u
Rcore_trim_RU53 core_trim_u5_21 core_trim_u5_22 vss 485.100000 ppolyf_u
Rcore_trim_RU54 core_trim_u5_22 core_trim_u5_23 vss 485.100000 ppolyf_u
Rcore_trim_RU55 core_trim_u5_23 core_trim_u5_24 vss 485.100000 ppolyf_u
Rcore_trim_RU56 core_trim_u5_24 core_trim_u5_25 vss 485.100000 ppolyf_u
Rcore_trim_RU57 core_trim_u5_25 core_trim_u5_26 vss 485.100000 ppolyf_u
Rcore_trim_RU58 core_trim_u5_26 core_trim_u5_27 vss 485.100000 ppolyf_u
Rcore_trim_RU59 core_trim_u5_27 core_trim_u5_28 vss 485.100000 ppolyf_u
Rcore_trim_RU6 core_trim_u2_2 core_tn0 vss 485.100000 ppolyf_u
Rcore_trim_RU60 core_trim_u5_28 core_trim_u5_29 vss 485.100000 ppolyf_u
Rcore_trim_RU61 core_trim_u5_29 core_trim_u5_30 vss 485.100000 ppolyf_u
Rcore_trim_RU62 core_trim_u5_30 vref vss 485.100000 ppolyf_u
Rcore_trim_RU7 core_tn0 core_trim_u3_0 vss 485.100000 ppolyf_u
Rcore_trim_RU8 core_trim_u3_0 core_trim_u3_1 vss 485.100000 ppolyf_u
Rcore_trim_RU9 core_trim_u3_1 core_trim_u3_2 vss 485.100000 ppolyf_u
Rstartup_RPU startup_det vdd vss 1999980.500000 ppolyf_u_1k
.ENDS bandgap_top
