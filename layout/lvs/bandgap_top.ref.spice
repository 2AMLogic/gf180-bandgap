* LVS reference netlist for bandgap_top -- GENERATED, do not edit.
*
* Produced by layout/lvs/make_reference.py from
* design/netlist/bandgap_top.spice. See that script's docstring for the
* seven mechanical transformations applied and why each one is a
* klt-extraction-deck capability consequence rather than a design
* simplification.
*
* drawn trim code : 32
* MOS devices     : 34 nfet + 47 pfet (14 of them edge dummies)

.SUBCKT bandgap_top vdd vss vref vsubs nwl
Mamp_M1_0 amp_n1 sns2 amp_tail vsubs nfet L=4U W=25U
Mamp_M1_1 amp_n1 sns2 amp_tail vsubs nfet L=4U W=25U
Mamp_M1_2 amp_n1 sns2 amp_tail vsubs nfet L=4U W=25U
Mamp_M1_3 amp_n1 sns2 amp_tail vsubs nfet L=4U W=25U
Mamp_M1_4 amp_n1 sns2 amp_tail vsubs nfet L=4U W=25U
Mamp_M1_5 amp_n1 sns2 amp_tail vsubs nfet L=4U W=25U
Mamp_M1_6 amp_n1 sns2 amp_tail vsubs nfet L=4U W=25U
Mamp_M1_7 amp_n1 sns2 amp_tail vsubs nfet L=4U W=25U
Mamp_M2_0 amp_n2 sns1 amp_tail vsubs nfet L=4U W=25U
Mamp_M2_1 amp_n2 sns1 amp_tail vsubs nfet L=4U W=25U
Mamp_M2_2 amp_n2 sns1 amp_tail vsubs nfet L=4U W=25U
Mamp_M2_3 amp_n2 sns1 amp_tail vsubs nfet L=4U W=25U
Mamp_M2_4 amp_n2 sns1 amp_tail vsubs nfet L=4U W=25U
Mamp_M2_5 amp_n2 sns1 amp_tail vsubs nfet L=4U W=25U
Mamp_M2_6 amp_n2 sns1 amp_tail vsubs nfet L=4U W=25U
Mamp_M2_7 amp_n2 sns1 amp_tail vsubs nfet L=4U W=25U
Mamp_M3_0 amp_a3 amp_nd1 vdd nwl pfet L=16U W=10U
Mamp_M3_1 amp_a3 amp_nd1 vdd nwl pfet L=16U W=10U
Mamp_M4_0 amp_a4 amp_nd1 vdd nwl pfet L=16U W=10U
Mamp_M4_1 amp_a4 amp_nd1 vdd nwl pfet L=16U W=10U
Mamp_M5_0 amp_tail ibias vss vsubs nfet L=4U W=10U
Mamp_MB1_0 amp_ncasc amp_pbias vdd nwl pfet L=50U W=5U
Mamp_MBD1_0 amp_ncasc amp_ncasc amp_nb1 vsubs nfet L=4U W=1U
Mamp_MBD2_0 amp_nb1 amp_nb1 vss vsubs nfet L=4U W=1U
Mamp_MBN2_0 amp_pbias ibias vss vsubs nfet L=16U W=2U
Mamp_MBP1_0 amp_pbias amp_pbias vdd nwl pfet L=50U W=1U
Mamp_MC1_0 amp_nd1 amp_ncasc amp_n1 vsubs nfet L=16U W=10U
Mamp_MC1_1 amp_nd1 amp_ncasc amp_n1 vsubs nfet L=16U W=10U
Mamp_MC2_0 fb amp_ncasc amp_n2 vsubs nfet L=16U W=10U
Mamp_MC2_1 fb amp_ncasc amp_n2 vsubs nfet L=16U W=10U
Mamp_MC3_0 amp_nd1 amp_pbias amp_a3 nwl pfet L=16U W=20U
Mamp_MC3_1 amp_nd1 amp_pbias amp_a3 nwl pfet L=16U W=20U
Mamp_MC4_0 fb amp_pbias amp_a4 nwl pfet L=16U W=20U
Mamp_MC4_1 fb amp_pbias amp_a4 nwl pfet L=16U W=20U
Mcore_M1_0 core_d1 fb vdd nwl pfet L=6U W=15U
Mcore_M1_1 core_d1 fb vdd nwl pfet L=6U W=15U
Mcore_M1_2 core_d1 fb vdd nwl pfet L=6U W=15U
Mcore_M1_3 core_d1 fb vdd nwl pfet L=6U W=15U
Mcore_M2_0 core_d2 fb vdd nwl pfet L=6U W=15U
Mcore_M2_1 core_d2 fb vdd nwl pfet L=6U W=15U
Mcore_M2_2 core_d2 fb vdd nwl pfet L=6U W=15U
Mcore_M2_3 core_d2 fb vdd nwl pfet L=6U W=15U
Mcore_M3_0 core_d3 fb vdd nwl pfet L=6U W=15U
Mcore_M3_1 core_d3 fb vdd nwl pfet L=6U W=15U
Mcore_M3_2 core_d3 fb vdd nwl pfet L=6U W=15U
Mcore_M3_3 core_d3 fb vdd nwl pfet L=6U W=15U
Mcore_M4_0 core_d4 fb vdd nwl pfet L=6U W=7.5U
Mcore_M5_0 ibias ibias vss vsubs nfet L=2U W=2.5U
Mcore_MC1_0 sns1 casc core_d1 nwl pfet L=6U W=15U
Mcore_MC1_1 sns1 casc core_d1 nwl pfet L=6U W=15U
Mcore_MC1_2 sns1 casc core_d1 nwl pfet L=6U W=15U
Mcore_MC1_3 sns1 casc core_d1 nwl pfet L=6U W=15U
Mcore_MC2_0 sns2 casc core_d2 nwl pfet L=6U W=15U
Mcore_MC2_1 sns2 casc core_d2 nwl pfet L=6U W=15U
Mcore_MC2_2 sns2 casc core_d2 nwl pfet L=6U W=15U
Mcore_MC2_3 sns2 casc core_d2 nwl pfet L=6U W=15U
Mcore_MC3_0 vref casc core_d3 nwl pfet L=6U W=15U
Mcore_MC3_1 vref casc core_d3 nwl pfet L=6U W=15U
Mcore_MC3_2 vref casc core_d3 nwl pfet L=6U W=15U
Mcore_MC3_3 vref casc core_d3 nwl pfet L=6U W=15U
Mcore_MC4_0 ibias casc core_d4 nwl pfet L=6U W=7.5U
Mcore_MCB_0 casc casc vdd nwl pfet L=12U W=4U
Mcore_MNB_0 casc ibias vss vsubs nfet L=2U W=5U
Mdum_ampload_l vdd vdd vdd nwl pfet L=16U W=2U
Mdum_ampload_r vdd vdd vdd nwl pfet L=16U W=2U
Mdum_ampncasc_l vss vss vss vsubs nfet L=16U W=2U
Mdum_ampncasc_r vss vss vss vsubs nfet L=16U W=2U
Mdum_amppair_l vss vss vss vsubs nfet L=4U W=2U
Mdum_amppair_r vss vss vss vsubs nfet L=4U W=2U
Mdum_amppcasc_l vdd vdd vdd nwl pfet L=16U W=2U
Mdum_amppcasc_r vdd vdd vdd nwl pfet L=16U W=2U
Mdum_corecasc_l vdd vdd vdd nwl pfet L=6U W=2U
Mdum_corecasc_r vdd vdd vdd nwl pfet L=6U W=2U
Mdum_coreibias_l vdd vdd vdd nwl pfet L=6U W=2U
Mdum_coreibias_r vdd vdd vdd nwl pfet L=6U W=2U
Mdum_coremirror_l vdd vdd vdd nwl pfet L=6U W=2U
Mdum_coremirror_r vdd vdd vdd nwl pfet L=6U W=2U
Mstartup_MKCASC_0 casc vdd vss vsubs nfet L=2U W=2U
Mstartup_MKFB_0 fb vdd vss vsubs nfet L=2U W=2U
Mstartup_MSENSE_0 vdd ibias vss vsubs nfet L=2U W=10U
Mstartup_MSENSE_1 vdd ibias vss vsubs nfet L=2U W=10U
.ENDS bandgap_top
